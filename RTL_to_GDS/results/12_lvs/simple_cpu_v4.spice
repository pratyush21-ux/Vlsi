* NGSPICE file created from simple_cpu_v4.ext - technology: sky130A

.subckt sky130_fd_sc_hd__decap_6 VPWR VGND VPB VNB
X0 VPWR VGND VPWR VPB sky130_fd_pr__pfet_01v8_hvt ad=0.2262 pd=2.26 as=0.4524 ps=4.52 w=0.87 l=1.97
X1 VGND VPWR VGND VNB sky130_fd_pr__nfet_01v8 ad=0.143 pd=1.62 as=0.286 ps=3.24 w=0.55 l=1.97
.ends

.subckt sky130_fd_sc_hd__decap_3 VPWR VGND VPB VNB
X0 VPWR VGND VPWR VPB sky130_fd_pr__pfet_01v8_hvt ad=0.2262 pd=2.26 as=0.4524 ps=4.52 w=0.87 l=0.59
X1 VGND VPWR VGND VNB sky130_fd_pr__nfet_01v8 ad=0.143 pd=1.62 as=0.286 ps=3.24 w=0.55 l=0.59
.ends

.subckt sky130_fd_sc_hd__buf_2 VPWR VGND X A VPB VNB
X0 VPWR a_27_47# X VPB sky130_fd_pr__pfet_01v8_hvt ad=0.265 pd=2.53 as=0.135 ps=1.27 w=1 l=0.15
X1 X a_27_47# VPWR VPB sky130_fd_pr__pfet_01v8_hvt ad=0.135 pd=1.27 as=0.149 ps=1.325 w=1 l=0.15
X2 VPWR A a_27_47# VPB sky130_fd_pr__pfet_01v8_hvt ad=0.149 pd=1.325 as=0.1664 ps=1.8 w=0.64 l=0.15
X3 X a_27_47# VGND VNB sky130_fd_pr__nfet_01v8 ad=0.08775 pd=0.92 as=0.097 ps=0.975 w=0.65 l=0.15
X4 VGND a_27_47# X VNB sky130_fd_pr__nfet_01v8 ad=0.17225 pd=1.83 as=0.08775 ps=0.92 w=0.65 l=0.15
X5 VGND A a_27_47# VNB sky130_fd_pr__nfet_01v8 ad=0.097 pd=0.975 as=0.1092 ps=1.36 w=0.42 l=0.15
.ends

.subckt sky130_fd_sc_hd__dlygate4sd3_1 X A VPB VNB VGND VPWR
X0 VPWR A a_49_47# VPB sky130_fd_pr__pfet_01v8_hvt ad=0.0567 pd=0.69 as=0.1092 ps=1.36 w=0.42 l=0.15
X1 VGND a_285_47# a_391_47# VNB sky130_fd_pr__nfet_01v8 ad=0.097 pd=0.975 as=0.1092 ps=1.36 w=0.42 l=0.5
X2 X a_391_47# VPWR VPB sky130_fd_pr__pfet_01v8_hvt ad=0.26 pd=2.52 as=0.14075 ps=1.325 w=1 l=0.15
X3 VGND A a_49_47# VNB sky130_fd_pr__nfet_01v8 ad=0.0567 pd=0.69 as=0.1092 ps=1.36 w=0.42 l=0.15
X4 VPWR a_285_47# a_391_47# VPB sky130_fd_pr__pfet_01v8_hvt ad=0.14075 pd=1.325 as=0.1092 ps=1.36 w=0.42 l=0.5
X5 a_285_47# a_49_47# VGND VNB sky130_fd_pr__nfet_01v8 ad=0.1092 pd=1.36 as=0.0567 ps=0.69 w=0.42 l=0.5
X6 a_285_47# a_49_47# VPWR VPB sky130_fd_pr__pfet_01v8_hvt ad=0.1092 pd=1.36 as=0.0567 ps=0.69 w=0.42 l=0.5
X7 X a_391_47# VGND VNB sky130_fd_pr__nfet_01v8 ad=0.169 pd=1.82 as=0.097 ps=0.975 w=0.65 l=0.15
.ends

.subckt sky130_fd_sc_hd__decap_12 VGND VPWR VPB VNB
X0 VPWR VGND VPWR VPB sky130_fd_pr__pfet_01v8_hvt ad=0.2262 pd=2.26 as=0.4524 ps=4.52 w=0.87 l=4.73
X1 VGND VPWR VGND VNB sky130_fd_pr__nfet_01v8 ad=0.143 pd=1.62 as=0.286 ps=3.24 w=0.55 l=4.73
.ends

.subckt sky130_fd_sc_hd__nand2_1 VPB VNB VGND VPWR A Y B
X0 VPWR A Y VPB sky130_fd_pr__pfet_01v8_hvt ad=0.26 pd=2.52 as=0.135 ps=1.27 w=1 l=0.15
X1 Y A a_113_47# VNB sky130_fd_pr__nfet_01v8 ad=0.169 pd=1.82 as=0.08775 ps=0.92 w=0.65 l=0.15
X2 a_113_47# B VGND VNB sky130_fd_pr__nfet_01v8 ad=0.08775 pd=0.92 as=0.169 ps=1.82 w=0.65 l=0.15
X3 Y B VPWR VPB sky130_fd_pr__pfet_01v8_hvt ad=0.135 pd=1.27 as=0.26 ps=2.52 w=1 l=0.15
.ends

.subckt sky130_fd_sc_hd__nand4_1 VPB VNB VPWR VGND A C D Y B
X0 Y B VPWR VPB sky130_fd_pr__pfet_01v8_hvt ad=0.165 pd=1.33 as=0.135 ps=1.27 w=1 l=0.15
X1 VPWR A Y VPB sky130_fd_pr__pfet_01v8_hvt ad=0.3 pd=2.6 as=0.165 ps=1.33 w=1 l=0.15
X2 VPWR C Y VPB sky130_fd_pr__pfet_01v8_hvt ad=0.135 pd=1.27 as=0.135 ps=1.27 w=1 l=0.15
X3 a_193_47# C a_109_47# VNB sky130_fd_pr__nfet_01v8 ad=0.08775 pd=0.92 as=0.08775 ps=0.92 w=0.65 l=0.15
X4 Y A a_277_47# VNB sky130_fd_pr__nfet_01v8 ad=0.195 pd=1.9 as=0.10725 ps=0.98 w=0.65 l=0.15
X5 a_277_47# B a_193_47# VNB sky130_fd_pr__nfet_01v8 ad=0.10725 pd=0.98 as=0.08775 ps=0.92 w=0.65 l=0.15
X6 Y D VPWR VPB sky130_fd_pr__pfet_01v8_hvt ad=0.135 pd=1.27 as=0.26 ps=2.52 w=1 l=0.15
X7 a_109_47# D VGND VNB sky130_fd_pr__nfet_01v8 ad=0.08775 pd=0.92 as=0.169 ps=1.82 w=0.65 l=0.15
.ends

.subckt sky130_fd_sc_hd__o221ai_1 VPB VNB VGND VPWR A1 A2 Y B2 C1 B1
X0 a_109_47# B1 a_213_123# VNB sky130_fd_pr__nfet_01v8 ad=0.08775 pd=0.92 as=0.1652 ps=1.82 w=0.65 l=0.15
X1 Y B2 a_295_297# VPB sky130_fd_pr__pfet_01v8_hvt ad=0.225 pd=1.45 as=0.12 ps=1.24 w=1 l=0.15
X2 VPWR A1 a_493_297# VPB sky130_fd_pr__pfet_01v8_hvt ad=0.26 pd=2.52 as=0.105 ps=1.21 w=1 l=0.15
X3 a_213_123# B2 a_109_47# VNB sky130_fd_pr__nfet_01v8 ad=0.117 pd=1.01 as=0.08775 ps=0.92 w=0.65 l=0.15
X4 a_295_297# B1 VPWR VPB sky130_fd_pr__pfet_01v8_hvt ad=0.12 pd=1.24 as=0.38 ps=1.76 w=1 l=0.15
X5 a_493_297# A2 Y VPB sky130_fd_pr__pfet_01v8_hvt ad=0.105 pd=1.21 as=0.225 ps=1.45 w=1 l=0.15
X6 VPWR C1 Y VPB sky130_fd_pr__pfet_01v8_hvt ad=0.38 pd=1.76 as=0.28 ps=2.56 w=1 l=0.15
X7 VGND A2 a_213_123# VNB sky130_fd_pr__nfet_01v8 ad=0.08775 pd=0.92 as=0.117 ps=1.01 w=0.65 l=0.15
X8 a_213_123# A1 VGND VNB sky130_fd_pr__nfet_01v8 ad=0.169 pd=1.82 as=0.08775 ps=0.92 w=0.65 l=0.15
X9 a_109_47# C1 Y VNB sky130_fd_pr__nfet_01v8 ad=0.1654 pd=1.82 as=0.169 ps=1.82 w=0.65 l=0.15
.ends

.subckt sky130_fd_sc_hd__o21ai_0 VNB VPB VGND VPWR B1 A1 Y A2
X0 a_120_369# A1 VPWR VPB sky130_fd_pr__pfet_01v8_hvt ad=0.0768 pd=0.88 as=0.1696 ps=1.81 w=0.64 l=0.15
X1 VGND A1 a_32_47# VNB sky130_fd_pr__nfet_01v8 ad=0.0588 pd=0.7 as=0.1113 ps=1.37 w=0.42 l=0.15
X2 Y A2 a_120_369# VPB sky130_fd_pr__pfet_01v8_hvt ad=0.0896 pd=0.92 as=0.0768 ps=0.88 w=0.64 l=0.15
X3 a_32_47# A2 VGND VNB sky130_fd_pr__nfet_01v8 ad=0.0588 pd=0.7 as=0.0588 ps=0.7 w=0.42 l=0.15
X4 VPWR B1 Y VPB sky130_fd_pr__pfet_01v8_hvt ad=0.1824 pd=1.85 as=0.0896 ps=0.92 w=0.64 l=0.15
X5 Y B1 a_32_47# VNB sky130_fd_pr__nfet_01v8 ad=0.1113 pd=1.37 as=0.0588 ps=0.7 w=0.42 l=0.15
.ends

.subckt sky130_fd_sc_hd__nor2b_1 VPB VNB VGND VPWR B_N A Y
X0 Y a_74_47# a_265_297# VPB sky130_fd_pr__pfet_01v8_hvt ad=0.26 pd=2.52 as=0.105 ps=1.21 w=1 l=0.15
X1 VPWR B_N a_74_47# VPB sky130_fd_pr__pfet_01v8_hvt ad=0.1573 pd=1.39 as=0.1092 ps=1.36 w=0.42 l=0.15
X2 a_265_297# A VPWR VPB sky130_fd_pr__pfet_01v8_hvt ad=0.105 pd=1.21 as=0.1573 ps=1.39 w=1 l=0.15
X3 Y A VGND VNB sky130_fd_pr__nfet_01v8 ad=0.08775 pd=0.92 as=0.10025 ps=0.985 w=0.65 l=0.15
X4 VGND B_N a_74_47# VNB sky130_fd_pr__nfet_01v8 ad=0.10025 pd=0.985 as=0.1092 ps=1.36 w=0.42 l=0.15
X5 VGND a_74_47# Y VNB sky130_fd_pr__nfet_01v8 ad=0.169 pd=1.82 as=0.08775 ps=0.92 w=0.65 l=0.15
.ends

.subckt sky130_fd_sc_hd__and2_0 VNB VPB VPWR VGND X B A
X0 VPWR B a_40_47# VPB sky130_fd_pr__pfet_01v8_hvt ad=0.1841 pd=1.26 as=0.0609 ps=0.71 w=0.42 l=0.15
X1 X a_40_47# VPWR VPB sky130_fd_pr__pfet_01v8_hvt ad=0.1696 pd=1.81 as=0.1841 ps=1.26 w=0.64 l=0.15
X2 VGND B a_123_47# VNB sky130_fd_pr__nfet_01v8 ad=0.0966 pd=0.88 as=0.0441 ps=0.63 w=0.42 l=0.15
X3 X a_40_47# VGND VNB sky130_fd_pr__nfet_01v8 ad=0.1113 pd=1.37 as=0.0966 ps=0.88 w=0.42 l=0.15
X4 a_123_47# A a_40_47# VNB sky130_fd_pr__nfet_01v8 ad=0.0441 pd=0.63 as=0.1113 ps=1.37 w=0.42 l=0.15
X5 a_40_47# A VPWR VPB sky130_fd_pr__pfet_01v8_hvt ad=0.0609 pd=0.71 as=0.1113 ps=1.37 w=0.42 l=0.15
.ends

.subckt sky130_fd_sc_hd__mux2_1 VGND VPWR VPB VNB X A1 S A0
X0 VPWR a_505_21# a_535_374# VPB sky130_fd_pr__pfet_01v8_hvt ad=0.0693 pd=0.75 as=0.0441 ps=0.63 w=0.42 l=0.15
X1 a_505_21# S VPWR VPB sky130_fd_pr__pfet_01v8_hvt ad=0.1176 pd=1.4 as=0.0693 ps=0.75 w=0.42 l=0.15
X2 a_218_374# S VPWR VPB sky130_fd_pr__pfet_01v8_hvt ad=0.07665 pd=0.785 as=0.15835 ps=1.395 w=0.42 l=0.15
X3 VGND a_505_21# a_439_47# VNB sky130_fd_pr__nfet_01v8 ad=0.1449 pd=1.11 as=0.0693 ps=0.75 w=0.42 l=0.15
X4 a_76_199# A0 a_218_374# VPB sky130_fd_pr__pfet_01v8_hvt ad=0.1932 pd=1.34 as=0.07665 ps=0.785 w=0.42 l=0.15
X5 a_505_21# S VGND VNB sky130_fd_pr__nfet_01v8 ad=0.1092 pd=1.36 as=0.1449 ps=1.11 w=0.42 l=0.15
X6 a_439_47# A0 a_76_199# VNB sky130_fd_pr__nfet_01v8 ad=0.0693 pd=0.75 as=0.09975 ps=0.895 w=0.42 l=0.15
X7 a_535_374# A1 a_76_199# VPB sky130_fd_pr__pfet_01v8_hvt ad=0.0441 pd=0.63 as=0.1932 ps=1.34 w=0.42 l=0.15
X8 a_76_199# A1 a_218_47# VNB sky130_fd_pr__nfet_01v8 ad=0.09975 pd=0.895 as=0.0693 ps=0.75 w=0.42 l=0.15
X9 a_218_47# S VGND VNB sky130_fd_pr__nfet_01v8 ad=0.0693 pd=0.75 as=0.11285 ps=1.045 w=0.42 l=0.15
X10 VPWR a_76_199# X VPB sky130_fd_pr__pfet_01v8_hvt ad=0.15835 pd=1.395 as=0.26 ps=2.52 w=1 l=0.15
X11 VGND a_76_199# X VNB sky130_fd_pr__nfet_01v8 ad=0.11285 pd=1.045 as=0.169 ps=1.82 w=0.65 l=0.15
.ends

.subckt sky130_fd_sc_hd__o211ai_1 VPB VNB VGND VPWR A1 Y C1 B1 A2
X0 a_110_297# A1 VPWR VPB sky130_fd_pr__pfet_01v8_hvt ad=0.105 pd=1.21 as=0.265 ps=2.53 w=1 l=0.15
X1 VGND A1 a_27_47# VNB sky130_fd_pr__nfet_01v8 ad=0.12675 pd=1.04 as=0.17225 ps=1.83 w=0.65 l=0.15
X2 Y A2 a_110_297# VPB sky130_fd_pr__pfet_01v8_hvt ad=0.195 pd=1.39 as=0.105 ps=1.21 w=1 l=0.15
X3 VPWR B1 Y VPB sky130_fd_pr__pfet_01v8_hvt ad=0.195 pd=1.39 as=0.195 ps=1.39 w=1 l=0.15
X4 a_27_47# A2 VGND VNB sky130_fd_pr__nfet_01v8 ad=0.12675 pd=1.04 as=0.12675 ps=1.04 w=0.65 l=0.15
X5 a_326_47# B1 a_27_47# VNB sky130_fd_pr__nfet_01v8 ad=0.06825 pd=0.86 as=0.12675 ps=1.04 w=0.65 l=0.15
X6 Y C1 VPWR VPB sky130_fd_pr__pfet_01v8_hvt ad=0.635 pd=3.27 as=0.195 ps=1.39 w=1 l=0.15
X7 Y C1 a_326_47# VNB sky130_fd_pr__nfet_01v8 ad=0.39325 pd=2.51 as=0.06825 ps=0.86 w=0.65 l=0.15
.ends

.subckt sky130_fd_sc_hd__o21a_1 VPB VNB VGND VPWR A1 A2 B1 X
X0 VPWR A1 a_382_297# VPB sky130_fd_pr__pfet_01v8_hvt ad=0.26 pd=2.52 as=0.1525 ps=1.305 w=1 l=0.15
X1 a_297_47# B1 a_79_21# VNB sky130_fd_pr__nfet_01v8 ad=0.10075 pd=0.96 as=0.169 ps=1.82 w=0.65 l=0.15
X2 a_297_47# A1 VGND VNB sky130_fd_pr__nfet_01v8 ad=0.169 pd=1.82 as=0.08775 ps=0.92 w=0.65 l=0.15
X3 VGND A2 a_297_47# VNB sky130_fd_pr__nfet_01v8 ad=0.08775 pd=0.92 as=0.10075 ps=0.96 w=0.65 l=0.15
X4 VPWR a_79_21# X VPB sky130_fd_pr__pfet_01v8_hvt ad=0.3275 pd=1.655 as=0.28 ps=2.56 w=1 l=0.15
X5 a_79_21# B1 VPWR VPB sky130_fd_pr__pfet_01v8_hvt ad=0.195 pd=1.39 as=0.3275 ps=1.655 w=1 l=0.15
X6 a_382_297# A2 a_79_21# VPB sky130_fd_pr__pfet_01v8_hvt ad=0.1525 pd=1.305 as=0.195 ps=1.39 w=1 l=0.15
X7 VGND a_79_21# X VNB sky130_fd_pr__nfet_01v8 ad=0.169 pd=1.82 as=0.169 ps=1.82 w=0.65 l=0.15
.ends

.subckt sky130_fd_sc_hd__decap_4 VGND VPWR VPB VNB
X0 VPWR VGND VPWR VPB sky130_fd_pr__pfet_01v8_hvt ad=0.2262 pd=2.26 as=0.4524 ps=4.52 w=0.87 l=1.05
X1 VGND VPWR VGND VNB sky130_fd_pr__nfet_01v8 ad=0.143 pd=1.62 as=0.286 ps=3.24 w=0.55 l=1.05
.ends

.subckt sky130_fd_sc_hd__a32oi_1 VGND VPWR VPB VNB B2 Y B1 A1 A2 A3
X0 VPWR A3 a_27_297# VPB sky130_fd_pr__pfet_01v8_hvt ad=0.26 pd=2.52 as=0.14 ps=1.28 w=1 l=0.15
X1 VGND A3 a_383_47# VNB sky130_fd_pr__nfet_01v8 ad=0.169 pd=1.82 as=0.10725 ps=0.98 w=0.65 l=0.15
X2 a_309_47# A1 Y VNB sky130_fd_pr__nfet_01v8 ad=0.0715 pd=0.87 as=0.15275 ps=1.12 w=0.65 l=0.15
X3 Y B1 a_109_47# VNB sky130_fd_pr__nfet_01v8 ad=0.15275 pd=1.12 as=0.07475 ps=0.88 w=0.65 l=0.15
X4 a_27_297# B1 Y VPB sky130_fd_pr__pfet_01v8_hvt ad=0.215 pd=1.43 as=0.135 ps=1.27 w=1 l=0.15
X5 a_383_47# A2 a_309_47# VNB sky130_fd_pr__nfet_01v8 ad=0.10725 pd=0.98 as=0.0715 ps=0.87 w=0.65 l=0.15
X6 a_27_297# A2 VPWR VPB sky130_fd_pr__pfet_01v8_hvt ad=0.14 pd=1.28 as=0.135 ps=1.27 w=1 l=0.15
X7 Y B2 a_27_297# VPB sky130_fd_pr__pfet_01v8_hvt ad=0.135 pd=1.27 as=0.26 ps=2.52 w=1 l=0.15
X8 VPWR A1 a_27_297# VPB sky130_fd_pr__pfet_01v8_hvt ad=0.135 pd=1.27 as=0.215 ps=1.43 w=1 l=0.15
X9 a_109_47# B2 VGND VNB sky130_fd_pr__nfet_01v8 ad=0.07475 pd=0.88 as=0.169 ps=1.82 w=0.65 l=0.15
.ends

.subckt sky130_fd_sc_hd__xor2_1 VNB VPB VPWR VGND A X B
X0 X a_35_297# a_285_297# VPB sky130_fd_pr__pfet_01v8_hvt ad=0.3 pd=2.6 as=0.26 ps=2.52 w=1 l=0.15
X1 X B a_285_47# VNB sky130_fd_pr__nfet_01v8 ad=0.25025 pd=1.42 as=0.08775 ps=0.92 w=0.65 l=0.15
X2 a_35_297# B VGND VNB sky130_fd_pr__nfet_01v8 ad=0.08775 pd=0.92 as=0.169 ps=1.82 w=0.65 l=0.15
X3 a_117_297# B a_35_297# VPB sky130_fd_pr__pfet_01v8_hvt ad=0.135 pd=1.27 as=0.26 ps=2.52 w=1 l=0.15
X4 VPWR B a_285_297# VPB sky130_fd_pr__pfet_01v8_hvt ad=0.26 pd=2.52 as=0.135 ps=1.27 w=1 l=0.15
X5 VGND A a_35_297# VNB sky130_fd_pr__nfet_01v8 ad=0.08775 pd=0.92 as=0.08775 ps=0.92 w=0.65 l=0.15
X6 VGND a_35_297# X VNB sky130_fd_pr__nfet_01v8 ad=0.208 pd=1.94 as=0.25025 ps=1.42 w=0.65 l=0.15
X7 a_285_297# A VPWR VPB sky130_fd_pr__pfet_01v8_hvt ad=0.135 pd=1.27 as=0.135 ps=1.27 w=1 l=0.15
X8 VPWR A a_117_297# VPB sky130_fd_pr__pfet_01v8_hvt ad=0.135 pd=1.27 as=0.135 ps=1.27 w=1 l=0.15
X9 a_285_47# A VGND VNB sky130_fd_pr__nfet_01v8 ad=0.08775 pd=0.92 as=0.08775 ps=0.92 w=0.65 l=0.15
.ends

.subckt sky130_fd_sc_hd__decap_8 VPWR VGND VPB VNB
X0 VPWR VGND VPWR VPB sky130_fd_pr__pfet_01v8_hvt ad=0.2262 pd=2.26 as=0.4524 ps=4.52 w=0.87 l=2.89
X1 VGND VPWR VGND VNB sky130_fd_pr__nfet_01v8 ad=0.143 pd=1.62 as=0.286 ps=3.24 w=0.55 l=2.89
.ends

.subckt sky130_fd_sc_hd__dfxtp_1 Q CLK D VPB VNB VPWR VGND
X0 Q a_1059_315# VGND VNB sky130_fd_pr__nfet_01v8 ad=0.169 pd=1.82 as=0.08775 ps=0.92 w=0.65 l=0.15
X1 a_891_413# a_193_47# a_634_159# VNB sky130_fd_pr__special_nfet_01v8 ad=0.0684 pd=0.74 as=0.0989 ps=0.995 w=0.36 l=0.15
X2 a_561_413# a_27_47# a_466_413# VPB sky130_fd_pr__pfet_01v8_hvt ad=0.07665 pd=0.785 as=0.06825 ps=0.745 w=0.42 l=0.15
X3 VPWR CLK a_27_47# VPB sky130_fd_pr__pfet_01v8_hvt ad=0.0864 pd=0.91 as=0.1664 ps=1.8 w=0.64 l=0.15
X4 Q a_1059_315# VPWR VPB sky130_fd_pr__pfet_01v8_hvt ad=0.26 pd=2.52 as=0.135 ps=1.27 w=1 l=0.15
X5 a_381_47# D VPWR VPB sky130_fd_pr__pfet_01v8_hvt ad=0.05775 pd=0.695 as=0.1092 ps=1.36 w=0.42 l=0.15
X6 VGND a_634_159# a_592_47# VNB sky130_fd_pr__nfet_01v8 ad=0.12095 pd=1.085 as=0.0696 ps=0.765 w=0.42 l=0.15
X7 VPWR a_891_413# a_1059_315# VPB sky130_fd_pr__pfet_01v8_hvt ad=0.135 pd=1.27 as=0.27 ps=2.54 w=1 l=0.15
X8 a_466_413# a_193_47# a_381_47# VPB sky130_fd_pr__pfet_01v8_hvt ad=0.06825 pd=0.745 as=0.05775 ps=0.695 w=0.42 l=0.15
X9 VPWR a_634_159# a_561_413# VPB sky130_fd_pr__pfet_01v8_hvt ad=0.17887 pd=1.26 as=0.07665 ps=0.785 w=0.42 l=0.15
X10 a_634_159# a_466_413# VGND VNB sky130_fd_pr__nfet_01v8 ad=0.0989 pd=0.995 as=0.12095 ps=1.085 w=0.64 l=0.15
X11 a_634_159# a_466_413# VPWR VPB sky130_fd_pr__pfet_01v8_hvt ad=0.1095 pd=1.075 as=0.17887 ps=1.26 w=0.75 l=0.15
X12 a_975_413# a_193_47# a_891_413# VPB sky130_fd_pr__pfet_01v8_hvt ad=0.0882 pd=0.84 as=0.0567 ps=0.69 w=0.42 l=0.15
X13 VGND a_1059_315# a_1017_47# VNB sky130_fd_pr__nfet_01v8 ad=0.1092 pd=1.36 as=0.066 ps=0.745 w=0.42 l=0.15
X14 a_193_47# a_27_47# VGND VNB sky130_fd_pr__nfet_01v8 ad=0.1092 pd=1.36 as=0.0567 ps=0.69 w=0.42 l=0.15
X15 a_891_413# a_27_47# a_634_159# VPB sky130_fd_pr__pfet_01v8_hvt ad=0.0567 pd=0.69 as=0.1095 ps=1.075 w=0.42 l=0.15
X16 a_592_47# a_193_47# a_466_413# VNB sky130_fd_pr__special_nfet_01v8 ad=0.0696 pd=0.765 as=0.0621 ps=0.705 w=0.36 l=0.15
X17 VPWR a_1059_315# a_975_413# VPB sky130_fd_pr__pfet_01v8_hvt ad=0.1113 pd=1.37 as=0.0882 ps=0.84 w=0.42 l=0.15
X18 a_1017_47# a_27_47# a_891_413# VNB sky130_fd_pr__special_nfet_01v8 ad=0.066 pd=0.745 as=0.0684 ps=0.74 w=0.36 l=0.15
X19 a_193_47# a_27_47# VPWR VPB sky130_fd_pr__pfet_01v8_hvt ad=0.1664 pd=1.8 as=0.0864 ps=0.91 w=0.64 l=0.15
X20 a_466_413# a_27_47# a_381_47# VNB sky130_fd_pr__special_nfet_01v8 ad=0.0621 pd=0.705 as=0.0813 ps=0.83 w=0.36 l=0.15
X21 VGND a_891_413# a_1059_315# VNB sky130_fd_pr__nfet_01v8 ad=0.08775 pd=0.92 as=0.169 ps=1.82 w=0.65 l=0.15
X22 a_381_47# D VGND VNB sky130_fd_pr__nfet_01v8 ad=0.0813 pd=0.83 as=0.1092 ps=1.36 w=0.42 l=0.15
X23 VGND CLK a_27_47# VNB sky130_fd_pr__nfet_01v8 ad=0.0567 pd=0.69 as=0.1092 ps=1.36 w=0.42 l=0.15
.ends

.subckt sky130_fd_sc_hd__edfxtp_1 VPWR VGND CLK DE Q D VPB VNB
X0 a_381_369# D a_299_47# VPB sky130_fd_pr__pfet_01v8_hvt ad=0.0672 pd=0.85 as=0.1664 ps=1.8 w=0.64 l=0.15
X1 VGND a_1591_413# a_791_264# VNB sky130_fd_pr__nfet_01v8 ad=0.10025 pd=0.985 as=0.1092 ps=1.36 w=0.42 l=0.15
X2 VPWR DE a_423_343# VPB sky130_fd_pr__pfet_01v8_hvt ad=0.0928 pd=0.93 as=0.1664 ps=1.8 w=0.64 l=0.15
X3 VPWR CLK a_27_47# VPB sky130_fd_pr__pfet_01v8_hvt ad=0.0864 pd=0.91 as=0.1664 ps=1.8 w=0.64 l=0.15
X4 a_1591_413# a_193_47# a_1514_47# VNB sky130_fd_pr__special_nfet_01v8 ad=0.0684 pd=0.74 as=0.0678 ps=0.755 w=0.36 l=0.15
X5 a_986_413# a_193_47# a_299_47# VPB sky130_fd_pr__pfet_01v8_hvt ad=0.06405 pd=0.725 as=0.15985 ps=1.265 w=0.42 l=0.15
X6 Q a_1591_413# VPWR VPB sky130_fd_pr__pfet_01v8_hvt ad=0.28 pd=2.56 as=0.154 ps=1.335 w=1 l=0.15
X7 VGND DE a_423_343# VNB sky130_fd_pr__nfet_01v8 ad=0.0609 pd=0.71 as=0.1092 ps=1.36 w=0.42 l=0.15
X8 a_1500_413# a_1150_159# VPWR VPB sky130_fd_pr__pfet_01v8_hvt ad=0.06405 pd=0.725 as=0.1092 ps=1.36 w=0.42 l=0.15
X9 a_1101_47# a_193_47# a_986_413# VNB sky130_fd_pr__special_nfet_01v8 ad=0.0759 pd=0.8 as=0.0522 ps=0.65 w=0.36 l=0.15
X10 a_1514_47# a_1150_159# VGND VNB sky130_fd_pr__nfet_01v8 ad=0.0678 pd=0.755 as=0.1092 ps=1.36 w=0.42 l=0.15
X11 a_1675_413# a_193_47# a_1591_413# VPB sky130_fd_pr__pfet_01v8_hvt ad=0.0882 pd=0.84 as=0.0567 ps=0.69 w=0.42 l=0.15
X12 a_193_47# a_27_47# VGND VNB sky130_fd_pr__nfet_01v8 ad=0.1092 pd=1.36 as=0.0567 ps=0.69 w=0.42 l=0.15
X13 a_1591_413# a_27_47# a_1500_413# VPB sky130_fd_pr__pfet_01v8_hvt ad=0.0567 pd=0.69 as=0.06405 ps=0.725 w=0.42 l=0.15
X14 a_729_47# a_423_343# VGND VNB sky130_fd_pr__nfet_01v8 ad=0.0756 pd=0.78 as=0.0609 ps=0.71 w=0.42 l=0.15
X15 a_729_369# DE VPWR VPB sky130_fd_pr__pfet_01v8_hvt ad=0.1152 pd=1 as=0.0928 ps=0.93 w=0.64 l=0.15
X16 a_1077_413# a_27_47# a_986_413# VPB sky130_fd_pr__pfet_01v8_hvt ad=0.07665 pd=0.785 as=0.06405 ps=0.725 w=0.42 l=0.15
X17 VPWR a_791_264# a_1675_413# VPB sky130_fd_pr__pfet_01v8_hvt ad=0.1113 pd=1.37 as=0.0882 ps=0.84 w=0.42 l=0.15
X18 Q a_1591_413# VGND VNB sky130_fd_pr__nfet_01v8 ad=0.182 pd=1.86 as=0.10025 ps=0.985 w=0.65 l=0.15
X19 a_299_47# a_791_264# a_729_47# VNB sky130_fd_pr__nfet_01v8 ad=0.1446 pd=1.18 as=0.0756 ps=0.78 w=0.42 l=0.15
X20 VPWR a_1591_413# a_791_264# VPB sky130_fd_pr__pfet_01v8_hvt ad=0.154 pd=1.335 as=0.1728 ps=1.82 w=0.64 l=0.15
X21 VGND a_791_264# a_1717_47# VNB sky130_fd_pr__nfet_01v8 ad=0.1092 pd=1.36 as=0.066 ps=0.745 w=0.42 l=0.15
X22 a_193_47# a_27_47# VPWR VPB sky130_fd_pr__pfet_01v8_hvt ad=0.1664 pd=1.8 as=0.0864 ps=0.91 w=0.64 l=0.15
X23 VPWR a_1150_159# a_1077_413# VPB sky130_fd_pr__pfet_01v8_hvt ad=0.17887 pd=1.26 as=0.07665 ps=0.785 w=0.42 l=0.15
X24 a_1717_47# a_27_47# a_1591_413# VNB sky130_fd_pr__special_nfet_01v8 ad=0.066 pd=0.745 as=0.0684 ps=0.74 w=0.36 l=0.15
X25 a_1150_159# a_986_413# VPWR VPB sky130_fd_pr__pfet_01v8_hvt ad=0.195 pd=2.02 as=0.17887 ps=1.26 w=0.75 l=0.15
X26 a_986_413# a_27_47# a_299_47# VNB sky130_fd_pr__special_nfet_01v8 ad=0.0522 pd=0.65 as=0.1446 ps=1.18 w=0.36 l=0.15
X27 a_299_47# a_791_264# a_729_369# VPB sky130_fd_pr__pfet_01v8_hvt ad=0.15985 pd=1.265 as=0.1152 ps=1 w=0.64 l=0.15
X28 a_381_47# D a_299_47# VNB sky130_fd_pr__nfet_01v8 ad=0.0441 pd=0.63 as=0.1092 ps=1.36 w=0.42 l=0.15
X29 VGND a_1150_159# a_1101_47# VNB sky130_fd_pr__nfet_01v8 ad=0.12095 pd=1.085 as=0.0759 ps=0.8 w=0.42 l=0.15
X30 VPWR a_423_343# a_381_369# VPB sky130_fd_pr__pfet_01v8_hvt ad=0.1664 pd=1.8 as=0.0672 ps=0.85 w=0.64 l=0.15
X31 VGND CLK a_27_47# VNB sky130_fd_pr__nfet_01v8 ad=0.0567 pd=0.69 as=0.1092 ps=1.36 w=0.42 l=0.15
X32 VGND DE a_381_47# VNB sky130_fd_pr__nfet_01v8 ad=0.1092 pd=1.36 as=0.0441 ps=0.63 w=0.42 l=0.15
X33 a_1150_159# a_986_413# VGND VNB sky130_fd_pr__nfet_01v8 ad=0.1664 pd=1.8 as=0.12095 ps=1.085 w=0.64 l=0.15
.ends

.subckt sky130_fd_sc_hd__nor4_2 VNB VPB VGND VPWR B D Y A C
X0 a_281_297# B a_27_297# VPB sky130_fd_pr__pfet_01v8_hvt ad=0.135 pd=1.27 as=0.135 ps=1.27 w=1 l=0.15
X1 Y B VGND VNB sky130_fd_pr__nfet_01v8 ad=0.08775 pd=0.92 as=0.08775 ps=0.92 w=0.65 l=0.15
X2 a_27_297# A VPWR VPB sky130_fd_pr__pfet_01v8_hvt ad=0.135 pd=1.27 as=0.135 ps=1.27 w=1 l=0.15
X3 a_475_297# D Y VPB sky130_fd_pr__pfet_01v8_hvt ad=0.26 pd=2.52 as=0.135 ps=1.27 w=1 l=0.15
X4 VGND C Y VNB sky130_fd_pr__nfet_01v8 ad=0.08775 pd=0.92 as=0.08775 ps=0.92 w=0.65 l=0.15
X5 Y D a_475_297# VPB sky130_fd_pr__pfet_01v8_hvt ad=0.135 pd=1.27 as=0.135 ps=1.27 w=1 l=0.15
X6 VGND D Y VNB sky130_fd_pr__nfet_01v8 ad=0.169 pd=1.82 as=0.08775 ps=0.92 w=0.65 l=0.15
X7 VGND A Y VNB sky130_fd_pr__nfet_01v8 ad=0.08775 pd=0.92 as=0.08775 ps=0.92 w=0.65 l=0.15
X8 Y A VGND VNB sky130_fd_pr__nfet_01v8 ad=0.08775 pd=0.92 as=0.182 ps=1.86 w=0.65 l=0.15
X9 VGND B Y VNB sky130_fd_pr__nfet_01v8 ad=0.182 pd=1.86 as=0.08775 ps=0.92 w=0.65 l=0.15
X10 Y D VGND VNB sky130_fd_pr__nfet_01v8 ad=0.08775 pd=0.92 as=0.08775 ps=0.92 w=0.65 l=0.15
X11 VPWR A a_27_297# VPB sky130_fd_pr__pfet_01v8_hvt ad=0.135 pd=1.27 as=0.28 ps=2.56 w=1 l=0.15
X12 a_475_297# C a_281_297# VPB sky130_fd_pr__pfet_01v8_hvt ad=0.135 pd=1.27 as=0.135 ps=1.27 w=1 l=0.15
X13 a_281_297# C a_475_297# VPB sky130_fd_pr__pfet_01v8_hvt ad=0.135 pd=1.27 as=0.28 ps=2.56 w=1 l=0.15
X14 a_27_297# B a_281_297# VPB sky130_fd_pr__pfet_01v8_hvt ad=0.28 pd=2.56 as=0.135 ps=1.27 w=1 l=0.15
X15 Y C VGND VNB sky130_fd_pr__nfet_01v8 ad=0.08775 pd=0.92 as=0.182 ps=1.86 w=0.65 l=0.15
.ends

.subckt sky130_fd_sc_hd__o21ai_1 VGND VPWR A2 B1 Y A1 VPB VNB
X0 Y A2 a_109_297# VPB sky130_fd_pr__pfet_01v8_hvt ad=0.174 pd=1.39 as=0.105 ps=1.21 w=1 l=0.15
X1 VPWR B1 Y VPB sky130_fd_pr__pfet_01v8_hvt ad=0.182 pd=1.92 as=0.174 ps=1.39 w=0.7 l=0.15
X2 a_27_47# A2 VGND VNB sky130_fd_pr__nfet_01v8 ad=0.08775 pd=0.92 as=0.10725 ps=0.98 w=0.65 l=0.15
X3 Y B1 a_27_47# VNB sky130_fd_pr__nfet_01v8 ad=0.169 pd=1.82 as=0.08775 ps=0.92 w=0.65 l=0.15
X4 a_109_297# A1 VPWR VPB sky130_fd_pr__pfet_01v8_hvt ad=0.105 pd=1.21 as=0.26 ps=2.52 w=1 l=0.15
X5 VGND A1 a_27_47# VNB sky130_fd_pr__nfet_01v8 ad=0.10725 pd=0.98 as=0.169 ps=1.82 w=0.65 l=0.15
.ends

.subckt sky130_fd_sc_hd__nor2_1 VPB VNB VGND VPWR A B Y
X0 VPWR A a_109_297# VPB sky130_fd_pr__pfet_01v8_hvt ad=0.26 pd=2.52 as=0.105 ps=1.21 w=1 l=0.15
X1 VGND A Y VNB sky130_fd_pr__nfet_01v8 ad=0.169 pd=1.82 as=0.08775 ps=0.92 w=0.65 l=0.15
X2 a_109_297# B Y VPB sky130_fd_pr__pfet_01v8_hvt ad=0.105 pd=1.21 as=0.26 ps=2.52 w=1 l=0.15
X3 Y B VGND VNB sky130_fd_pr__nfet_01v8 ad=0.08775 pd=0.92 as=0.169 ps=1.82 w=0.65 l=0.15
.ends

.subckt sky130_fd_sc_hd__buf_4 VPWR VGND X A VPB VNB
X0 VPWR a_27_47# X VPB sky130_fd_pr__pfet_01v8_hvt ad=0.26 pd=2.52 as=0.135 ps=1.27 w=1 l=0.15
X1 X a_27_47# VPWR VPB sky130_fd_pr__pfet_01v8_hvt ad=0.135 pd=1.27 as=0.135 ps=1.27 w=1 l=0.15
X2 VPWR a_27_47# X VPB sky130_fd_pr__pfet_01v8_hvt ad=0.135 pd=1.27 as=0.135 ps=1.27 w=1 l=0.15
X3 X a_27_47# VPWR VPB sky130_fd_pr__pfet_01v8_hvt ad=0.135 pd=1.27 as=0.135 ps=1.27 w=1 l=0.15
X4 X a_27_47# VGND VNB sky130_fd_pr__nfet_01v8 ad=0.08775 pd=0.92 as=0.08775 ps=0.92 w=0.65 l=0.15
X5 X a_27_47# VGND VNB sky130_fd_pr__nfet_01v8 ad=0.08775 pd=0.92 as=0.08775 ps=0.92 w=0.65 l=0.15
X6 VGND a_27_47# X VNB sky130_fd_pr__nfet_01v8 ad=0.08775 pd=0.92 as=0.08775 ps=0.92 w=0.65 l=0.15
X7 VGND a_27_47# X VNB sky130_fd_pr__nfet_01v8 ad=0.169 pd=1.82 as=0.08775 ps=0.92 w=0.65 l=0.15
X8 VPWR A a_27_47# VPB sky130_fd_pr__pfet_01v8_hvt ad=0.135 pd=1.27 as=0.26 ps=2.52 w=1 l=0.15
X9 VGND A a_27_47# VNB sky130_fd_pr__nfet_01v8 ad=0.08775 pd=0.92 as=0.169 ps=1.82 w=0.65 l=0.15
.ends

.subckt sky130_fd_sc_hd__a22oi_1 VPWR VGND VPB VNB B2 B1 Y A1 A2
X0 Y B1 a_109_47# VNB sky130_fd_pr__nfet_01v8 ad=0.169 pd=1.82 as=0.07475 ps=0.88 w=0.65 l=0.15
X1 Y B1 a_109_297# VPB sky130_fd_pr__pfet_01v8_hvt ad=0.26 pd=2.52 as=0.135 ps=1.27 w=1 l=0.15
X2 VPWR A2 a_109_297# VPB sky130_fd_pr__pfet_01v8_hvt ad=0.3 pd=2.6 as=0.135 ps=1.27 w=1 l=0.15
X3 a_109_297# A1 VPWR VPB sky130_fd_pr__pfet_01v8_hvt ad=0.135 pd=1.27 as=0.26 ps=2.52 w=1 l=0.15
X4 a_381_47# A1 Y VNB sky130_fd_pr__nfet_01v8 ad=0.06825 pd=0.86 as=0.169 ps=1.82 w=0.65 l=0.15
X5 a_109_297# B2 Y VPB sky130_fd_pr__pfet_01v8_hvt ad=0.135 pd=1.27 as=0.26 ps=2.52 w=1 l=0.15
X6 a_109_47# B2 VGND VNB sky130_fd_pr__nfet_01v8 ad=0.07475 pd=0.88 as=0.169 ps=1.82 w=0.65 l=0.15
X7 VGND A2 a_381_47# VNB sky130_fd_pr__nfet_01v8 ad=0.234 pd=2.02 as=0.06825 ps=0.86 w=0.65 l=0.15
.ends

.subckt sky130_fd_sc_hd__clkbuf_16 VNB VPB VGND VPWR A X
X0 VPWR A a_110_47# VPB sky130_fd_pr__pfet_01v8_hvt ad=0.14 pd=1.28 as=0.14 ps=1.28 w=1 l=0.15
X1 VPWR a_110_47# X VPB sky130_fd_pr__pfet_01v8_hvt ad=0.14 pd=1.28 as=0.14 ps=1.28 w=1 l=0.15
X2 X a_110_47# VPWR VPB sky130_fd_pr__pfet_01v8_hvt ad=0.14 pd=1.28 as=0.14 ps=1.28 w=1 l=0.15
X3 X a_110_47# VPWR VPB sky130_fd_pr__pfet_01v8_hvt ad=0.14 pd=1.28 as=0.14 ps=1.28 w=1 l=0.15
X4 VPWR a_110_47# X VPB sky130_fd_pr__pfet_01v8_hvt ad=0.14 pd=1.28 as=0.14 ps=1.28 w=1 l=0.15
X5 VPWR a_110_47# X VPB sky130_fd_pr__pfet_01v8_hvt ad=0.265 pd=2.53 as=0.14 ps=1.28 w=1 l=0.15
X6 a_110_47# A VPWR VPB sky130_fd_pr__pfet_01v8_hvt ad=0.14 pd=1.28 as=0.265 ps=2.53 w=1 l=0.15
X7 a_110_47# A VGND VNB sky130_fd_pr__nfet_01v8 ad=0.0588 pd=0.7 as=0.0588 ps=0.7 w=0.42 l=0.15
X8 VGND a_110_47# X VNB sky130_fd_pr__nfet_01v8 ad=0.0588 pd=0.7 as=0.0588 ps=0.7 w=0.42 l=0.15
X9 X a_110_47# VGND VNB sky130_fd_pr__nfet_01v8 ad=0.0588 pd=0.7 as=0.0588 ps=0.7 w=0.42 l=0.15
X10 VGND a_110_47# X VNB sky130_fd_pr__nfet_01v8 ad=0.0588 pd=0.7 as=0.0588 ps=0.7 w=0.42 l=0.15
X11 a_110_47# A VPWR VPB sky130_fd_pr__pfet_01v8_hvt ad=0.14 pd=1.28 as=0.14 ps=1.28 w=1 l=0.15
X12 VGND A a_110_47# VNB sky130_fd_pr__nfet_01v8 ad=0.0588 pd=0.7 as=0.0588 ps=0.7 w=0.42 l=0.15
X13 VGND a_110_47# X VNB sky130_fd_pr__nfet_01v8 ad=0.05775 pd=0.695 as=0.0588 ps=0.7 w=0.42 l=0.15
X14 VPWR a_110_47# X VPB sky130_fd_pr__pfet_01v8_hvt ad=0.14 pd=1.28 as=0.14 ps=1.28 w=1 l=0.15
X15 X a_110_47# VPWR VPB sky130_fd_pr__pfet_01v8_hvt ad=0.14 pd=1.28 as=0.14 ps=1.28 w=1 l=0.15
X16 VGND A a_110_47# VNB sky130_fd_pr__nfet_01v8 ad=0.0588 pd=0.7 as=0.0588 ps=0.7 w=0.42 l=0.15
X17 VGND a_110_47# X VNB sky130_fd_pr__nfet_01v8 ad=0.1113 pd=1.37 as=0.0588 ps=0.7 w=0.42 l=0.15
X18 VPWR a_110_47# X VPB sky130_fd_pr__pfet_01v8_hvt ad=0.1375 pd=1.275 as=0.14 ps=1.28 w=1 l=0.15
X19 VGND a_110_47# X VNB sky130_fd_pr__nfet_01v8 ad=0.0588 pd=0.7 as=0.0588 ps=0.7 w=0.42 l=0.15
X20 X a_110_47# VPWR VPB sky130_fd_pr__pfet_01v8_hvt ad=0.14 pd=1.28 as=0.1375 ps=1.275 w=1 l=0.15
X21 a_110_47# A VGND VNB sky130_fd_pr__nfet_01v8 ad=0.0588 pd=0.7 as=0.1113 ps=1.37 w=0.42 l=0.15
X22 VPWR A a_110_47# VPB sky130_fd_pr__pfet_01v8_hvt ad=0.14 pd=1.28 as=0.14 ps=1.28 w=1 l=0.15
X23 VPWR a_110_47# X VPB sky130_fd_pr__pfet_01v8_hvt ad=0.14 pd=1.28 as=0.14 ps=1.28 w=1 l=0.15
X24 VPWR a_110_47# X VPB sky130_fd_pr__pfet_01v8_hvt ad=0.14 pd=1.28 as=0.14 ps=1.28 w=1 l=0.15
X25 VGND a_110_47# X VNB sky130_fd_pr__nfet_01v8 ad=0.0588 pd=0.7 as=0.0588 ps=0.7 w=0.42 l=0.15
X26 X a_110_47# VPWR VPB sky130_fd_pr__pfet_01v8_hvt ad=0.14 pd=1.28 as=0.14 ps=1.28 w=1 l=0.15
X27 VGND a_110_47# X VNB sky130_fd_pr__nfet_01v8 ad=0.0588 pd=0.7 as=0.0588 ps=0.7 w=0.42 l=0.15
X28 VGND a_110_47# X VNB sky130_fd_pr__nfet_01v8 ad=0.0588 pd=0.7 as=0.0588 ps=0.7 w=0.42 l=0.15
X29 X a_110_47# VGND VNB sky130_fd_pr__nfet_01v8 ad=0.0588 pd=0.7 as=0.0588 ps=0.7 w=0.42 l=0.15
X30 X a_110_47# VPWR VPB sky130_fd_pr__pfet_01v8_hvt ad=0.14 pd=1.28 as=0.14 ps=1.28 w=1 l=0.15
X31 X a_110_47# VPWR VPB sky130_fd_pr__pfet_01v8_hvt ad=0.14 pd=1.28 as=0.14 ps=1.28 w=1 l=0.15
X32 X a_110_47# VGND VNB sky130_fd_pr__nfet_01v8 ad=0.0588 pd=0.7 as=0.0588 ps=0.7 w=0.42 l=0.15
X33 VPWR a_110_47# X VPB sky130_fd_pr__pfet_01v8_hvt ad=0.14 pd=1.28 as=0.14 ps=1.28 w=1 l=0.15
X34 X a_110_47# VPWR VPB sky130_fd_pr__pfet_01v8_hvt ad=0.14 pd=1.28 as=0.14 ps=1.28 w=1 l=0.15
X35 X a_110_47# VGND VNB sky130_fd_pr__nfet_01v8 ad=0.0588 pd=0.7 as=0.0588 ps=0.7 w=0.42 l=0.15
X36 X a_110_47# VGND VNB sky130_fd_pr__nfet_01v8 ad=0.0588 pd=0.7 as=0.0588 ps=0.7 w=0.42 l=0.15
X37 X a_110_47# VGND VNB sky130_fd_pr__nfet_01v8 ad=0.0588 pd=0.7 as=0.0588 ps=0.7 w=0.42 l=0.15
X38 X a_110_47# VGND VNB sky130_fd_pr__nfet_01v8 ad=0.0588 pd=0.7 as=0.0588 ps=0.7 w=0.42 l=0.15
X39 X a_110_47# VGND VNB sky130_fd_pr__nfet_01v8 ad=0.0588 pd=0.7 as=0.05775 ps=0.695 w=0.42 l=0.15
.ends

.subckt sky130_fd_sc_hd__a21oi_1 VPWR VGND VPB VNB A2 A1 B1 Y
X0 a_199_47# A1 Y VNB sky130_fd_pr__nfet_01v8 ad=0.09588 pd=0.945 as=0.091 ps=0.93 w=0.65 l=0.15
X1 a_113_297# A2 VPWR VPB sky130_fd_pr__pfet_01v8_hvt ad=0.265 pd=2.53 as=0.1475 ps=1.295 w=1 l=0.15
X2 Y B1 VGND VNB sky130_fd_pr__nfet_01v8 ad=0.091 pd=0.93 as=0.17225 ps=1.83 w=0.65 l=0.15
X3 VPWR A1 a_113_297# VPB sky130_fd_pr__pfet_01v8_hvt ad=0.1475 pd=1.295 as=0.14 ps=1.28 w=1 l=0.15
X4 a_113_297# B1 Y VPB sky130_fd_pr__pfet_01v8_hvt ad=0.14 pd=1.28 as=0.265 ps=2.53 w=1 l=0.15
X5 VGND A2 a_199_47# VNB sky130_fd_pr__nfet_01v8 ad=0.17225 pd=1.83 as=0.09588 ps=0.945 w=0.65 l=0.15
.ends

.subckt sky130_fd_sc_hd__xnor2_1 VGND VPWR B Y A VPB VNB
X0 a_377_297# A VPWR VPB sky130_fd_pr__pfet_01v8_hvt ad=0.105 pd=1.21 as=0.365 ps=1.73 w=1 l=0.15
X1 a_47_47# B VPWR VPB sky130_fd_pr__pfet_01v8_hvt ad=0.135 pd=1.27 as=0.3 ps=2.6 w=1 l=0.15
X2 a_129_47# B a_47_47# VNB sky130_fd_pr__nfet_01v8 ad=0.06825 pd=0.86 as=0.169 ps=1.82 w=0.65 l=0.15
X3 a_285_47# B VGND VNB sky130_fd_pr__nfet_01v8 ad=0.08775 pd=0.92 as=0.169 ps=1.82 w=0.65 l=0.15
X4 Y a_47_47# a_285_47# VNB sky130_fd_pr__nfet_01v8 ad=0.195 pd=1.9 as=0.08775 ps=0.92 w=0.65 l=0.15
X5 VGND A a_129_47# VNB sky130_fd_pr__nfet_01v8 ad=0.08775 pd=0.92 as=0.06825 ps=0.86 w=0.65 l=0.15
X6 VPWR A a_47_47# VPB sky130_fd_pr__pfet_01v8_hvt ad=0.365 pd=1.73 as=0.135 ps=1.27 w=1 l=0.15
X7 VPWR a_47_47# Y VPB sky130_fd_pr__pfet_01v8_hvt ad=0.36 pd=2.72 as=0.165 ps=1.33 w=1 l=0.15
X8 Y B a_377_297# VPB sky130_fd_pr__pfet_01v8_hvt ad=0.165 pd=1.33 as=0.105 ps=1.21 w=1 l=0.15
X9 a_285_47# A VGND VNB sky130_fd_pr__nfet_01v8 ad=0.169 pd=1.82 as=0.08775 ps=0.92 w=0.65 l=0.15
.ends

.subckt sky130_fd_sc_hd__nand2b_1 VPB VNB VGND VPWR A_N B Y
X0 VGND A_N a_27_93# VNB sky130_fd_pr__nfet_01v8 ad=0.10025 pd=0.985 as=0.1092 ps=1.36 w=0.42 l=0.15
X1 Y a_27_93# a_206_47# VNB sky130_fd_pr__nfet_01v8 ad=0.169 pd=1.82 as=0.08775 ps=0.92 w=0.65 l=0.15
X2 a_206_47# B VGND VNB sky130_fd_pr__nfet_01v8 ad=0.08775 pd=0.92 as=0.10025 ps=0.985 w=0.65 l=0.15
X3 VPWR a_27_93# Y VPB sky130_fd_pr__pfet_01v8_hvt ad=0.265 pd=2.53 as=0.135 ps=1.27 w=1 l=0.15
X4 Y B VPWR VPB sky130_fd_pr__pfet_01v8_hvt ad=0.135 pd=1.27 as=0.14575 ps=1.335 w=1 l=0.15
X5 VPWR A_N a_27_93# VPB sky130_fd_pr__pfet_01v8_hvt ad=0.14575 pd=1.335 as=0.1092 ps=1.36 w=0.42 l=0.15
.ends

.subckt sky130_fd_sc_hd__mux2i_1 VPB VNB VGND VPWR A0 Y A1 S
X0 a_27_297# S VPWR VPB sky130_fd_pr__pfet_01v8_hvt ad=0.26 pd=2.52 as=0.3 ps=1.6 w=1 l=0.15
X1 VGND S a_283_205# VNB sky130_fd_pr__nfet_01v8 ad=0.169 pd=1.82 as=0.169 ps=1.82 w=0.65 l=0.15
X2 a_204_297# A1 Y VPB sky130_fd_pr__pfet_01v8_hvt ad=0.1975 pd=1.395 as=0.1525 ps=1.305 w=1 l=0.15
X3 a_193_47# A1 Y VNB sky130_fd_pr__nfet_01v8 ad=0.182 pd=1.86 as=0.08775 ps=0.92 w=0.65 l=0.15
X4 Y A0 a_27_297# VPB sky130_fd_pr__pfet_01v8_hvt ad=0.1525 pd=1.305 as=0.28 ps=2.56 w=1 l=0.15
X5 VPWR a_283_205# a_204_297# VPB sky130_fd_pr__pfet_01v8_hvt ad=0.3 pd=1.6 as=0.1975 ps=1.395 w=1 l=0.15
X6 VPWR S a_283_205# VPB sky130_fd_pr__pfet_01v8_hvt ad=0.26 pd=2.52 as=0.29 ps=2.58 w=1 l=0.15
X7 VGND a_283_205# a_27_47# VNB sky130_fd_pr__nfet_01v8 ad=0.08775 pd=0.92 as=0.169 ps=1.82 w=0.65 l=0.15
X8 a_193_47# S VGND VNB sky130_fd_pr__nfet_01v8 ad=0.169 pd=1.82 as=0.08775 ps=0.92 w=0.65 l=0.15
X9 Y A0 a_27_47# VNB sky130_fd_pr__nfet_01v8 ad=0.08775 pd=0.92 as=0.169 ps=1.82 w=0.65 l=0.15
.ends

.subckt sky130_fd_sc_hd__maj3_1 VPB VNB VGND VPWR X C A B
X0 X a_27_47# VGND VNB sky130_fd_pr__nfet_01v8 ad=0.23725 pd=2.03 as=0.1474 ps=1.215 w=0.65 l=0.15
X1 X a_27_47# VPWR VPB sky130_fd_pr__pfet_01v8_hvt ad=0.365 pd=2.73 as=0.2492 ps=1.565 w=1 l=0.15
X2 a_109_341# C a_27_47# VPB sky130_fd_pr__pfet_01v8_hvt ad=0.0441 pd=0.63 as=0.1092 ps=1.36 w=0.42 l=0.15
X3 a_27_47# B a_265_341# VPB sky130_fd_pr__pfet_01v8_hvt ad=0.0567 pd=0.69 as=0.0441 ps=0.63 w=0.42 l=0.15
X4 VGND A a_109_47# VNB sky130_fd_pr__nfet_01v8 ad=0.0567 pd=0.69 as=0.0441 ps=0.63 w=0.42 l=0.15
X5 a_265_341# A VPWR VPB sky130_fd_pr__pfet_01v8_hvt ad=0.0441 pd=0.63 as=0.0567 ps=0.69 w=0.42 l=0.15
X6 VPWR A a_109_341# VPB sky130_fd_pr__pfet_01v8_hvt ad=0.0567 pd=0.69 as=0.0441 ps=0.63 w=0.42 l=0.15
X7 a_421_47# B a_27_47# VNB sky130_fd_pr__nfet_01v8 ad=0.0441 pd=0.63 as=0.0567 ps=0.69 w=0.42 l=0.15
X8 a_265_47# A VGND VNB sky130_fd_pr__nfet_01v8 ad=0.0441 pd=0.63 as=0.0567 ps=0.69 w=0.42 l=0.15
X9 VGND C a_421_47# VNB sky130_fd_pr__nfet_01v8 ad=0.1474 pd=1.215 as=0.0441 ps=0.63 w=0.42 l=0.15
X10 a_27_47# B a_265_47# VNB sky130_fd_pr__nfet_01v8 ad=0.0567 pd=0.69 as=0.0441 ps=0.63 w=0.42 l=0.15
X11 VPWR C a_421_341# VPB sky130_fd_pr__pfet_01v8_hvt ad=0.2492 pd=1.565 as=0.0441 ps=0.63 w=0.42 l=0.15
X12 a_421_341# B a_27_47# VPB sky130_fd_pr__pfet_01v8_hvt ad=0.0441 pd=0.63 as=0.0567 ps=0.69 w=0.42 l=0.15
X13 a_109_47# C a_27_47# VNB sky130_fd_pr__nfet_01v8 ad=0.0441 pd=0.63 as=0.1092 ps=1.36 w=0.42 l=0.15
.ends

.subckt sky130_fd_sc_hd__nor3_2 VPB VNB VGND VPWR A B C Y
X0 Y C a_281_297# VPB sky130_fd_pr__pfet_01v8_hvt ad=0.135 pd=1.27 as=0.26 ps=2.52 w=1 l=0.15
X1 a_281_297# B a_27_297# VPB sky130_fd_pr__pfet_01v8_hvt ad=0.135 pd=1.27 as=0.135 ps=1.27 w=1 l=0.15
X2 Y B VGND VNB sky130_fd_pr__nfet_01v8 ad=0.08775 pd=0.92 as=0.08775 ps=0.92 w=0.65 l=0.15
X3 a_27_297# A VPWR VPB sky130_fd_pr__pfet_01v8_hvt ad=0.135 pd=1.27 as=0.135 ps=1.27 w=1 l=0.15
X4 VGND A Y VNB sky130_fd_pr__nfet_01v8 ad=0.08775 pd=0.92 as=0.08775 ps=0.92 w=0.65 l=0.15
X5 Y A VGND VNB sky130_fd_pr__nfet_01v8 ad=0.08775 pd=0.92 as=0.17875 ps=1.85 w=0.65 l=0.15
X6 VGND B Y VNB sky130_fd_pr__nfet_01v8 ad=0.169 pd=1.82 as=0.08775 ps=0.92 w=0.65 l=0.15
X7 VGND C Y VNB sky130_fd_pr__nfet_01v8 ad=0.169 pd=1.82 as=0.08775 ps=0.92 w=0.65 l=0.15
X8 Y C VGND VNB sky130_fd_pr__nfet_01v8 ad=0.08775 pd=0.92 as=0.169 ps=1.82 w=0.65 l=0.15
X9 VPWR A a_27_297# VPB sky130_fd_pr__pfet_01v8_hvt ad=0.135 pd=1.27 as=0.28 ps=2.56 w=1 l=0.15
X10 a_281_297# C Y VPB sky130_fd_pr__pfet_01v8_hvt ad=0.26 pd=2.52 as=0.135 ps=1.27 w=1 l=0.15
X11 a_27_297# B a_281_297# VPB sky130_fd_pr__pfet_01v8_hvt ad=0.28 pd=2.56 as=0.135 ps=1.27 w=1 l=0.15
.ends

.subckt sky130_fd_sc_hd__mux4_2 VNB VPB VGND VPWR S0 A2 A3 S1 A1 A0 X
X0 a_600_345# S1 VPWR VPB sky130_fd_pr__pfet_01v8_hvt ad=0.1664 pd=1.8 as=0.0864 ps=0.91 w=0.64 l=0.15
X1 a_788_316# S1 a_288_47# VNB sky130_fd_pr__nfet_01v8 ad=0.05775 pd=0.695 as=0.1092 ps=1.36 w=0.42 l=0.15
X2 VPWR A3 a_372_413# VPB sky130_fd_pr__pfet_01v8_hvt ad=0.0864 pd=0.91 as=0.1645 ps=1.33 w=0.64 l=0.15
X3 a_872_316# a_600_345# a_788_316# VNB sky130_fd_pr__nfet_01v8 ad=0.1092 pd=1.36 as=0.05775 ps=0.695 w=0.42 l=0.15
X4 VPWR S0 a_27_47# VPB sky130_fd_pr__pfet_01v8_hvt ad=0.0864 pd=0.91 as=0.1664 ps=1.8 w=0.64 l=0.15
X5 a_1279_413# S0 a_872_316# VPB sky130_fd_pr__pfet_01v8_hvt ad=0.10535 pd=0.995 as=0.0567 ps=0.69 w=0.42 l=0.15
X6 VGND a_788_316# X VNB sky130_fd_pr__nfet_01v8 ad=0.221 pd=1.98 as=0.08775 ps=0.92 w=0.65 l=0.15
X7 a_1060_369# A1 VPWR VPB sky130_fd_pr__pfet_01v8_hvt ad=0.13775 pd=1.165 as=0.1664 ps=1.8 w=0.64 l=0.15
X8 a_872_316# a_27_47# a_1060_369# VPB sky130_fd_pr__pfet_01v8_hvt ad=0.0567 pd=0.69 as=0.13775 ps=1.165 w=0.42 l=0.15
X9 a_193_47# A2 VGND VNB sky130_fd_pr__nfet_01v8 ad=0.066 pd=0.745 as=0.0567 ps=0.69 w=0.42 l=0.15
X10 a_1064_47# A1 VGND VNB sky130_fd_pr__nfet_01v8 ad=0.0786 pd=0.805 as=0.1092 ps=1.36 w=0.42 l=0.15
X11 a_1281_47# a_27_47# a_872_316# VNB sky130_fd_pr__special_nfet_01v8 ad=0.066 pd=0.745 as=0.072 ps=0.76 w=0.36 l=0.15
X12 a_872_316# S1 a_788_316# VPB sky130_fd_pr__pfet_01v8_hvt ad=0.1404 pd=1.6 as=0.0729 ps=0.81 w=0.54 l=0.15
X13 a_872_316# S0 a_1064_47# VNB sky130_fd_pr__special_nfet_01v8 ad=0.072 pd=0.76 as=0.0786 ps=0.805 w=0.36 l=0.15
X14 X a_788_316# VGND VNB sky130_fd_pr__nfet_01v8 ad=0.08775 pd=0.92 as=0.10675 ps=1.005 w=0.65 l=0.15
X15 a_788_316# a_600_345# a_288_47# VPB sky130_fd_pr__pfet_01v8_hvt ad=0.0729 pd=0.81 as=0.1404 ps=1.6 w=0.54 l=0.15
X16 a_372_413# a_27_47# a_288_47# VPB sky130_fd_pr__pfet_01v8_hvt ad=0.1645 pd=1.33 as=0.0567 ps=0.69 w=0.42 l=0.15
X17 VGND A3 a_397_47# VNB sky130_fd_pr__nfet_01v8 ad=0.0819 pd=0.81 as=0.06705 ps=0.75 w=0.42 l=0.15
X18 a_600_345# S1 VGND VNB sky130_fd_pr__nfet_01v8 ad=0.1134 pd=1.38 as=0.0819 ps=0.81 w=0.42 l=0.15
X19 a_193_369# A2 VPWR VPB sky130_fd_pr__pfet_01v8_hvt ad=0.09575 pd=0.965 as=0.0864 ps=0.91 w=0.64 l=0.15
X20 VPWR a_788_316# X VPB sky130_fd_pr__pfet_01v8_hvt ad=0.34 pd=2.68 as=0.135 ps=1.27 w=1 l=0.15
X21 a_288_47# S0 a_193_369# VPB sky130_fd_pr__pfet_01v8_hvt ad=0.0567 pd=0.69 as=0.09575 ps=0.965 w=0.42 l=0.15
X22 VGND A0 a_1281_47# VNB sky130_fd_pr__nfet_01v8 ad=0.10675 pd=1.005 as=0.066 ps=0.745 w=0.42 l=0.15
X23 a_397_47# S0 a_288_47# VNB sky130_fd_pr__special_nfet_01v8 ad=0.06705 pd=0.75 as=0.0711 ps=0.755 w=0.36 l=0.15
X24 X a_788_316# VPWR VPB sky130_fd_pr__pfet_01v8_hvt ad=0.135 pd=1.27 as=0.154 ps=1.335 w=1 l=0.15
X25 a_288_47# a_27_47# a_193_47# VNB sky130_fd_pr__special_nfet_01v8 ad=0.0711 pd=0.755 as=0.066 ps=0.745 w=0.36 l=0.15
X26 VGND S0 a_27_47# VNB sky130_fd_pr__nfet_01v8 ad=0.0567 pd=0.69 as=0.1092 ps=1.36 w=0.42 l=0.15
X27 VPWR A0 a_1279_413# VPB sky130_fd_pr__pfet_01v8_hvt ad=0.154 pd=1.335 as=0.10535 ps=0.995 w=0.64 l=0.15
.ends

.subckt sky130_fd_sc_hd__nor2_2 VPB VNB VGND VPWR B Y A
X0 Y B a_27_297# VPB sky130_fd_pr__pfet_01v8_hvt ad=0.135 pd=1.27 as=0.135 ps=1.27 w=1 l=0.15
X1 Y B VGND VNB sky130_fd_pr__nfet_01v8 ad=0.08775 pd=0.92 as=0.08775 ps=0.92 w=0.65 l=0.15
X2 a_27_297# A VPWR VPB sky130_fd_pr__pfet_01v8_hvt ad=0.135 pd=1.27 as=0.135 ps=1.27 w=1 l=0.15
X3 VGND A Y VNB sky130_fd_pr__nfet_01v8 ad=0.08775 pd=0.92 as=0.08775 ps=0.92 w=0.65 l=0.15
X4 Y A VGND VNB sky130_fd_pr__nfet_01v8 ad=0.08775 pd=0.92 as=0.182 ps=1.86 w=0.65 l=0.15
X5 VGND B Y VNB sky130_fd_pr__nfet_01v8 ad=0.169 pd=1.82 as=0.08775 ps=0.92 w=0.65 l=0.15
X6 VPWR A a_27_297# VPB sky130_fd_pr__pfet_01v8_hvt ad=0.135 pd=1.27 as=0.28 ps=2.56 w=1 l=0.15
X7 a_27_297# B Y VPB sky130_fd_pr__pfet_01v8_hvt ad=0.26 pd=2.52 as=0.135 ps=1.27 w=1 l=0.15
.ends

.subckt sky130_fd_sc_hd__a21o_1 VPWR VGND VPB VNB A2 A1 B1 X
X0 a_81_21# B1 VGND VNB sky130_fd_pr__nfet_01v8 ad=0.08937 pd=0.925 as=0.25675 ps=1.44 w=0.65 l=0.15
X1 a_299_297# B1 a_81_21# VPB sky130_fd_pr__pfet_01v8_hvt ad=0.1375 pd=1.275 as=0.26 ps=2.52 w=1 l=0.15
X2 VPWR a_81_21# X VPB sky130_fd_pr__pfet_01v8_hvt ad=0.26 pd=2.52 as=0.26 ps=2.52 w=1 l=0.15
X3 VPWR A1 a_299_297# VPB sky130_fd_pr__pfet_01v8_hvt ad=0.14 pd=1.28 as=0.1375 ps=1.275 w=1 l=0.15
X4 VGND a_81_21# X VNB sky130_fd_pr__nfet_01v8 ad=0.25675 pd=1.44 as=0.169 ps=1.82 w=0.65 l=0.15
X5 VGND A2 a_384_47# VNB sky130_fd_pr__nfet_01v8 ad=0.17225 pd=1.83 as=0.091 ps=0.93 w=0.65 l=0.15
X6 a_299_297# A2 VPWR VPB sky130_fd_pr__pfet_01v8_hvt ad=0.265 pd=2.53 as=0.14 ps=1.28 w=1 l=0.15
X7 a_384_47# A1 a_81_21# VNB sky130_fd_pr__nfet_01v8 ad=0.091 pd=0.93 as=0.08937 ps=0.925 w=0.65 l=0.15
.ends

.subckt sky130_fd_sc_hd__a221oi_2 VNB VPB VGND VPWR A2 A1 B1 B2 Y C1
X0 Y B1 a_383_47# VNB sky130_fd_pr__nfet_01v8 ad=0.08775 pd=0.92 as=0.08775 ps=0.92 w=0.65 l=0.15
X1 a_301_297# B1 a_27_297# VPB sky130_fd_pr__pfet_01v8_hvt ad=0.135 pd=1.27 as=0.135 ps=1.27 w=1 l=0.15
X2 a_301_297# A2 VPWR VPB sky130_fd_pr__pfet_01v8_hvt ad=0.285 pd=2.57 as=0.135 ps=1.27 w=1 l=0.15
X3 VGND B2 a_383_47# VNB sky130_fd_pr__nfet_01v8 ad=0.11375 pd=1 as=0.08775 ps=0.92 w=0.65 l=0.15
X4 Y A1 a_735_47# VNB sky130_fd_pr__nfet_01v8 ad=0.08775 pd=0.92 as=0.08775 ps=0.92 w=0.65 l=0.15
X5 a_27_297# B2 a_301_297# VPB sky130_fd_pr__pfet_01v8_hvt ad=0.135 pd=1.27 as=0.26 ps=2.52 w=1 l=0.15
X6 VPWR A1 a_301_297# VPB sky130_fd_pr__pfet_01v8_hvt ad=0.135 pd=1.27 as=0.135 ps=1.27 w=1 l=0.15
X7 VGND A2 a_735_47# VNB sky130_fd_pr__nfet_01v8 ad=0.169 pd=1.82 as=0.08775 ps=0.92 w=0.65 l=0.15
X8 a_301_297# A1 VPWR VPB sky130_fd_pr__pfet_01v8_hvt ad=0.135 pd=1.27 as=0.135 ps=1.27 w=1 l=0.15
X9 Y C1 a_27_297# VPB sky130_fd_pr__pfet_01v8_hvt ad=0.135 pd=1.27 as=0.27 ps=2.54 w=1 l=0.15
X10 VGND C1 Y VNB sky130_fd_pr__nfet_01v8 ad=0.25675 pd=1.44 as=0.08775 ps=0.92 w=0.65 l=0.15
X11 Y C1 VGND VNB sky130_fd_pr__nfet_01v8 ad=0.08775 pd=0.92 as=0.1755 ps=1.84 w=0.65 l=0.15
X12 VPWR A2 a_301_297# VPB sky130_fd_pr__pfet_01v8_hvt ad=0.135 pd=1.27 as=0.175 ps=1.35 w=1 l=0.15
X13 a_383_47# B2 VGND VNB sky130_fd_pr__nfet_01v8 ad=0.08775 pd=0.92 as=0.25675 ps=1.44 w=0.65 l=0.15
X14 a_383_47# B1 Y VNB sky130_fd_pr__nfet_01v8 ad=0.08775 pd=0.92 as=0.08775 ps=0.92 w=0.65 l=0.15
X15 a_735_47# A2 VGND VNB sky130_fd_pr__nfet_01v8 ad=0.08775 pd=0.92 as=0.11375 ps=1 w=0.65 l=0.15
X16 a_27_297# C1 Y VPB sky130_fd_pr__pfet_01v8_hvt ad=0.26 pd=2.52 as=0.135 ps=1.27 w=1 l=0.15
X17 a_301_297# B2 a_27_297# VPB sky130_fd_pr__pfet_01v8_hvt ad=0.175 pd=1.35 as=0.135 ps=1.27 w=1 l=0.15
X18 a_735_47# A1 Y VNB sky130_fd_pr__nfet_01v8 ad=0.08775 pd=0.92 as=0.08775 ps=0.92 w=0.65 l=0.15
X19 a_27_297# B1 a_301_297# VPB sky130_fd_pr__pfet_01v8_hvt ad=0.135 pd=1.27 as=0.135 ps=1.27 w=1 l=0.15
.ends

.subckt sky130_fd_sc_hd__a31oi_1 VGND VPWR VPB VNB A3 A2 A1 Y B1
X0 Y A1 a_181_47# VNB sky130_fd_pr__nfet_01v8 ad=0.10563 pd=0.975 as=0.11863 ps=1.015 w=0.65 l=0.15
X1 a_181_47# A2 a_109_47# VNB sky130_fd_pr__nfet_01v8 ad=0.11863 pd=1.015 as=0.06825 ps=0.86 w=0.65 l=0.15
X2 VGND B1 Y VNB sky130_fd_pr__nfet_01v8 ad=0.1755 pd=1.84 as=0.10563 ps=0.975 w=0.65 l=0.15
X3 VPWR A2 a_109_297# VPB sky130_fd_pr__pfet_01v8_hvt ad=0.1525 pd=1.305 as=0.135 ps=1.27 w=1 l=0.15
X4 Y B1 a_109_297# VPB sky130_fd_pr__pfet_01v8_hvt ad=0.27 pd=2.54 as=0.1625 ps=1.325 w=1 l=0.15
X5 a_109_297# A1 VPWR VPB sky130_fd_pr__pfet_01v8_hvt ad=0.1625 pd=1.325 as=0.1525 ps=1.305 w=1 l=0.15
X6 a_109_297# A3 VPWR VPB sky130_fd_pr__pfet_01v8_hvt ad=0.135 pd=1.27 as=0.26 ps=2.52 w=1 l=0.15
X7 a_109_47# A3 VGND VNB sky130_fd_pr__nfet_01v8 ad=0.06825 pd=0.86 as=0.169 ps=1.82 w=0.65 l=0.15
.ends

.subckt sky130_fd_sc_hd__dfxtp_2 Q CLK D VPB VNB VPWR VGND
X0 Q a_1059_315# VGND VNB sky130_fd_pr__nfet_01v8 ad=0.08775 pd=0.92 as=0.08775 ps=0.92 w=0.65 l=0.15
X1 VPWR a_1059_315# Q VPB sky130_fd_pr__pfet_01v8_hvt ad=0.26 pd=2.52 as=0.135 ps=1.27 w=1 l=0.15
X2 a_891_413# a_193_47# a_634_159# VNB sky130_fd_pr__special_nfet_01v8 ad=0.0684 pd=0.74 as=0.0989 ps=0.995 w=0.36 l=0.15
X3 a_561_413# a_27_47# a_466_413# VPB sky130_fd_pr__pfet_01v8_hvt ad=0.07665 pd=0.785 as=0.06825 ps=0.745 w=0.42 l=0.15
X4 VPWR CLK a_27_47# VPB sky130_fd_pr__pfet_01v8_hvt ad=0.0864 pd=0.91 as=0.1664 ps=1.8 w=0.64 l=0.15
X5 Q a_1059_315# VPWR VPB sky130_fd_pr__pfet_01v8_hvt ad=0.135 pd=1.27 as=0.135 ps=1.27 w=1 l=0.15
X6 a_381_47# D VPWR VPB sky130_fd_pr__pfet_01v8_hvt ad=0.05775 pd=0.695 as=0.1092 ps=1.36 w=0.42 l=0.15
X7 VGND a_634_159# a_592_47# VNB sky130_fd_pr__nfet_01v8 ad=0.12095 pd=1.085 as=0.0696 ps=0.765 w=0.42 l=0.15
X8 VGND a_1059_315# Q VNB sky130_fd_pr__nfet_01v8 ad=0.169 pd=1.82 as=0.08775 ps=0.92 w=0.65 l=0.15
X9 VPWR a_891_413# a_1059_315# VPB sky130_fd_pr__pfet_01v8_hvt ad=0.135 pd=1.27 as=0.27 ps=2.54 w=1 l=0.15
X10 a_466_413# a_193_47# a_381_47# VPB sky130_fd_pr__pfet_01v8_hvt ad=0.06825 pd=0.745 as=0.05775 ps=0.695 w=0.42 l=0.15
X11 VPWR a_634_159# a_561_413# VPB sky130_fd_pr__pfet_01v8_hvt ad=0.17887 pd=1.26 as=0.07665 ps=0.785 w=0.42 l=0.15
X12 a_634_159# a_466_413# VGND VNB sky130_fd_pr__nfet_01v8 ad=0.0989 pd=0.995 as=0.12095 ps=1.085 w=0.64 l=0.15
X13 a_634_159# a_466_413# VPWR VPB sky130_fd_pr__pfet_01v8_hvt ad=0.1095 pd=1.075 as=0.17887 ps=1.26 w=0.75 l=0.15
X14 a_975_413# a_193_47# a_891_413# VPB sky130_fd_pr__pfet_01v8_hvt ad=0.0882 pd=0.84 as=0.0567 ps=0.69 w=0.42 l=0.15
X15 VGND a_1059_315# a_1017_47# VNB sky130_fd_pr__nfet_01v8 ad=0.1092 pd=1.36 as=0.066 ps=0.745 w=0.42 l=0.15
X16 a_193_47# a_27_47# VGND VNB sky130_fd_pr__nfet_01v8 ad=0.1092 pd=1.36 as=0.0567 ps=0.69 w=0.42 l=0.15
X17 a_891_413# a_27_47# a_634_159# VPB sky130_fd_pr__pfet_01v8_hvt ad=0.0567 pd=0.69 as=0.1095 ps=1.075 w=0.42 l=0.15
X18 a_592_47# a_193_47# a_466_413# VNB sky130_fd_pr__special_nfet_01v8 ad=0.0696 pd=0.765 as=0.0621 ps=0.705 w=0.36 l=0.15
X19 VPWR a_1059_315# a_975_413# VPB sky130_fd_pr__pfet_01v8_hvt ad=0.1113 pd=1.37 as=0.0882 ps=0.84 w=0.42 l=0.15
X20 a_1017_47# a_27_47# a_891_413# VNB sky130_fd_pr__special_nfet_01v8 ad=0.066 pd=0.745 as=0.0684 ps=0.74 w=0.36 l=0.15
X21 a_193_47# a_27_47# VPWR VPB sky130_fd_pr__pfet_01v8_hvt ad=0.1664 pd=1.8 as=0.0864 ps=0.91 w=0.64 l=0.15
X22 a_466_413# a_27_47# a_381_47# VNB sky130_fd_pr__special_nfet_01v8 ad=0.0621 pd=0.705 as=0.0813 ps=0.83 w=0.36 l=0.15
X23 VGND a_891_413# a_1059_315# VNB sky130_fd_pr__nfet_01v8 ad=0.08775 pd=0.92 as=0.169 ps=1.82 w=0.65 l=0.15
X24 a_381_47# D VGND VNB sky130_fd_pr__nfet_01v8 ad=0.0813 pd=0.83 as=0.1092 ps=1.36 w=0.42 l=0.15
X25 VGND CLK a_27_47# VNB sky130_fd_pr__nfet_01v8 ad=0.0567 pd=0.69 as=0.1092 ps=1.36 w=0.42 l=0.15
.ends

.subckt sky130_fd_sc_hd__inv_1 VPB VNB VGND VPWR A Y
X0 Y A VGND VNB sky130_fd_pr__nfet_01v8 ad=0.169 pd=1.82 as=0.169 ps=1.82 w=0.65 l=0.15
X1 Y A VPWR VPB sky130_fd_pr__pfet_01v8_hvt ad=0.26 pd=2.52 as=0.26 ps=2.52 w=1 l=0.15
.ends

.subckt sky130_fd_sc_hd__clkbuf_8 X A VPB VNB VGND VPWR
X0 VPWR A a_110_47# VPB sky130_fd_pr__pfet_01v8_hvt ad=0.14 pd=1.28 as=0.14 ps=1.28 w=1 l=0.15
X1 VPWR a_110_47# X VPB sky130_fd_pr__pfet_01v8_hvt ad=0.14 pd=1.28 as=0.14 ps=1.28 w=1 l=0.15
X2 X a_110_47# VPWR VPB sky130_fd_pr__pfet_01v8_hvt ad=0.14 pd=1.28 as=0.14 ps=1.28 w=1 l=0.15
X3 a_110_47# A VPWR VPB sky130_fd_pr__pfet_01v8_hvt ad=0.14 pd=1.28 as=0.265 ps=2.53 w=1 l=0.15
X4 X a_110_47# VGND VNB sky130_fd_pr__nfet_01v8 ad=0.0588 pd=0.7 as=0.0588 ps=0.7 w=0.42 l=0.15
X5 X a_110_47# VPWR VPB sky130_fd_pr__pfet_01v8_hvt ad=0.14 pd=1.28 as=0.14 ps=1.28 w=1 l=0.15
X6 VGND a_110_47# X VNB sky130_fd_pr__nfet_01v8 ad=0.0588 pd=0.7 as=0.0588 ps=0.7 w=0.42 l=0.15
X7 VPWR a_110_47# X VPB sky130_fd_pr__pfet_01v8_hvt ad=0.14 pd=1.28 as=0.14 ps=1.28 w=1 l=0.15
X8 VGND A a_110_47# VNB sky130_fd_pr__nfet_01v8 ad=0.0588 pd=0.7 as=0.0588 ps=0.7 w=0.42 l=0.15
X9 VGND a_110_47# X VNB sky130_fd_pr__nfet_01v8 ad=0.1134 pd=1.38 as=0.0588 ps=0.7 w=0.42 l=0.15
X10 a_110_47# A VGND VNB sky130_fd_pr__nfet_01v8 ad=0.0588 pd=0.7 as=0.1113 ps=1.37 w=0.42 l=0.15
X11 VPWR a_110_47# X VPB sky130_fd_pr__pfet_01v8_hvt ad=0.14 pd=1.28 as=0.14 ps=1.28 w=1 l=0.15
X12 X a_110_47# VPWR VPB sky130_fd_pr__pfet_01v8_hvt ad=0.14 pd=1.28 as=0.14 ps=1.28 w=1 l=0.15
X13 VGND a_110_47# X VNB sky130_fd_pr__nfet_01v8 ad=0.0588 pd=0.7 as=0.0588 ps=0.7 w=0.42 l=0.15
X14 VGND a_110_47# X VNB sky130_fd_pr__nfet_01v8 ad=0.0588 pd=0.7 as=0.0588 ps=0.7 w=0.42 l=0.15
X15 X a_110_47# VPWR VPB sky130_fd_pr__pfet_01v8_hvt ad=0.14 pd=1.28 as=0.14 ps=1.28 w=1 l=0.15
X16 X a_110_47# VGND VNB sky130_fd_pr__nfet_01v8 ad=0.0588 pd=0.7 as=0.0588 ps=0.7 w=0.42 l=0.15
X17 VPWR a_110_47# X VPB sky130_fd_pr__pfet_01v8_hvt ad=0.265 pd=2.53 as=0.14 ps=1.28 w=1 l=0.15
X18 X a_110_47# VGND VNB sky130_fd_pr__nfet_01v8 ad=0.0588 pd=0.7 as=0.0588 ps=0.7 w=0.42 l=0.15
X19 X a_110_47# VGND VNB sky130_fd_pr__nfet_01v8 ad=0.0588 pd=0.7 as=0.0588 ps=0.7 w=0.42 l=0.15
.ends

.subckt sky130_fd_sc_hd__o32a_1 VPB VNB VPWR VGND X A1 A2 A3 B2 B1
X0 a_77_199# B2 a_227_47# VNB sky130_fd_pr__nfet_01v8 ad=0.13325 pd=1.06 as=0.12675 ps=1.04 w=0.65 l=0.15
X1 a_323_297# A2 a_227_297# VPB sky130_fd_pr__pfet_01v8_hvt ad=0.195 pd=1.39 as=0.165 ps=1.33 w=1 l=0.15
X2 a_227_297# A1 VPWR VPB sky130_fd_pr__pfet_01v8_hvt ad=0.165 pd=1.33 as=0.135 ps=1.27 w=1 l=0.15
X3 a_227_47# B1 a_77_199# VNB sky130_fd_pr__nfet_01v8 ad=0.1885 pd=1.88 as=0.13325 ps=1.06 w=0.65 l=0.15
X4 VGND a_77_199# X VNB sky130_fd_pr__nfet_01v8 ad=0.08775 pd=0.92 as=0.169 ps=1.82 w=0.65 l=0.15
X5 VPWR B1 a_539_297# VPB sky130_fd_pr__pfet_01v8_hvt ad=0.29 pd=2.58 as=0.205 ps=1.41 w=1 l=0.15
X6 a_227_47# A3 VGND VNB sky130_fd_pr__nfet_01v8 ad=0.12675 pd=1.04 as=0.12675 ps=1.04 w=0.65 l=0.15
X7 VPWR a_77_199# X VPB sky130_fd_pr__pfet_01v8_hvt ad=0.135 pd=1.27 as=0.335 ps=2.67 w=1 l=0.15
X8 a_77_199# A3 a_323_297# VPB sky130_fd_pr__pfet_01v8_hvt ad=0.195 pd=1.39 as=0.195 ps=1.39 w=1 l=0.15
X9 VGND A2 a_227_47# VNB sky130_fd_pr__nfet_01v8 ad=0.12675 pd=1.04 as=0.10725 ps=0.98 w=0.65 l=0.15
X10 a_227_47# A1 VGND VNB sky130_fd_pr__nfet_01v8 ad=0.10725 pd=0.98 as=0.08775 ps=0.92 w=0.65 l=0.15
X11 a_539_297# B2 a_77_199# VPB sky130_fd_pr__pfet_01v8_hvt ad=0.205 pd=1.41 as=0.195 ps=1.39 w=1 l=0.15
.ends

.subckt sky130_fd_sc_hd__clkdlybuf4s15_1 VGND VPWR X A VPB VNB
X0 VPWR A a_27_47# VPB sky130_fd_pr__pfet_01v8_hvt ad=0.346 pd=1.71 as=0.265 ps=2.53 w=1 l=0.15
X1 a_282_47# a_27_47# VGND VNB sky130_fd_pr__nfet_01v8 ad=0.17225 pd=1.83 as=0.22212 ps=1.36 w=0.65 l=0.15
X2 X a_394_47# VGND VNB sky130_fd_pr__nfet_01v8 ad=0.1113 pd=1.37 as=0.2181 ps=1.36 w=0.42 l=0.15
X3 VGND a_282_47# a_394_47# VNB sky130_fd_pr__nfet_01v8 ad=0.2181 pd=1.36 as=0.17225 ps=1.83 w=0.65 l=0.15
X4 X a_394_47# VPWR VPB sky130_fd_pr__pfet_01v8_hvt ad=0.265 pd=2.53 as=0.3406 ps=1.71 w=1 l=0.15
X5 a_282_47# a_27_47# VPWR VPB sky130_fd_pr__pfet_01v8_hvt ad=0.2173 pd=2.17 as=0.346 ps=1.71 w=0.82 l=0.15
X6 VGND A a_27_47# VNB sky130_fd_pr__nfet_01v8 ad=0.22212 pd=1.36 as=0.1113 ps=1.37 w=0.42 l=0.15
X7 VPWR a_282_47# a_394_47# VPB sky130_fd_pr__pfet_01v8_hvt ad=0.3406 pd=1.71 as=0.2173 ps=2.17 w=0.82 l=0.15
.ends

.subckt sky130_fd_sc_hd__clkbuf_4 VGND VPWR A X VPB VNB
X0 VPWR A a_27_47# VPB sky130_fd_pr__pfet_01v8_hvt ad=0.165 pd=1.33 as=0.265 ps=2.53 w=1 l=0.15
X1 VGND a_27_47# X VNB sky130_fd_pr__nfet_01v8 ad=0.1218 pd=1.42 as=0.0588 ps=0.7 w=0.42 l=0.15
X2 VGND a_27_47# X VNB sky130_fd_pr__nfet_01v8 ad=0.0588 pd=0.7 as=0.0588 ps=0.7 w=0.42 l=0.15
X3 X a_27_47# VPWR VPB sky130_fd_pr__pfet_01v8_hvt ad=0.14 pd=1.28 as=0.14 ps=1.28 w=1 l=0.15
X4 X a_27_47# VGND VNB sky130_fd_pr__nfet_01v8 ad=0.0588 pd=0.7 as=0.0588 ps=0.7 w=0.42 l=0.15
X5 VGND A a_27_47# VNB sky130_fd_pr__nfet_01v8 ad=0.07035 pd=0.755 as=0.1113 ps=1.37 w=0.42 l=0.15
X6 VPWR a_27_47# X VPB sky130_fd_pr__pfet_01v8_hvt ad=0.3 pd=2.6 as=0.14 ps=1.28 w=1 l=0.15
X7 X a_27_47# VGND VNB sky130_fd_pr__nfet_01v8 ad=0.0588 pd=0.7 as=0.07035 ps=0.755 w=0.42 l=0.15
X8 X a_27_47# VPWR VPB sky130_fd_pr__pfet_01v8_hvt ad=0.14 pd=1.28 as=0.165 ps=1.33 w=1 l=0.15
X9 VPWR a_27_47# X VPB sky130_fd_pr__pfet_01v8_hvt ad=0.14 pd=1.28 as=0.14 ps=1.28 w=1 l=0.15
.ends

.subckt sky130_fd_sc_hd__and3_1 VGND VPWR X B A C VPB VNB
X0 VPWR A a_27_47# VPB sky130_fd_pr__pfet_01v8_hvt ad=0.0567 pd=0.69 as=0.1092 ps=1.36 w=0.42 l=0.15
X1 VPWR C a_27_47# VPB sky130_fd_pr__pfet_01v8_hvt ad=0.14222 pd=1.335 as=0.06615 ps=0.735 w=0.42 l=0.15
X2 a_181_47# B a_109_47# VNB sky130_fd_pr__nfet_01v8 ad=0.0441 pd=0.63 as=0.0441 ps=0.63 w=0.42 l=0.15
X3 VGND C a_181_47# VNB sky130_fd_pr__nfet_01v8 ad=0.13165 pd=1.14 as=0.0441 ps=0.63 w=0.42 l=0.15
X4 a_27_47# B VPWR VPB sky130_fd_pr__pfet_01v8_hvt ad=0.06615 pd=0.735 as=0.0567 ps=0.69 w=0.42 l=0.15
X5 X a_27_47# VPWR VPB sky130_fd_pr__pfet_01v8_hvt ad=0.26 pd=2.52 as=0.14222 ps=1.335 w=1 l=0.15
X6 X a_27_47# VGND VNB sky130_fd_pr__nfet_01v8 ad=0.169 pd=1.82 as=0.13165 ps=1.14 w=0.65 l=0.15
X7 a_109_47# A a_27_47# VNB sky130_fd_pr__nfet_01v8 ad=0.0441 pd=0.63 as=0.1092 ps=1.36 w=0.42 l=0.15
.ends

.subckt sky130_fd_sc_hd__inv_6 VPB VNB VPWR VGND Y A
X0 VPWR A Y VPB sky130_fd_pr__pfet_01v8_hvt ad=0.27 pd=2.54 as=0.135 ps=1.27 w=1 l=0.15
X1 Y A VPWR VPB sky130_fd_pr__pfet_01v8_hvt ad=0.135 pd=1.27 as=0.135 ps=1.27 w=1 l=0.15
X2 Y A VGND VNB sky130_fd_pr__nfet_01v8 ad=0.08775 pd=0.92 as=0.08775 ps=0.92 w=0.65 l=0.15
X3 VPWR A Y VPB sky130_fd_pr__pfet_01v8_hvt ad=0.135 pd=1.27 as=0.135 ps=1.27 w=1 l=0.15
X4 Y A VPWR VPB sky130_fd_pr__pfet_01v8_hvt ad=0.135 pd=1.27 as=0.135 ps=1.27 w=1 l=0.15
X5 VPWR A Y VPB sky130_fd_pr__pfet_01v8_hvt ad=0.135 pd=1.27 as=0.135 ps=1.27 w=1 l=0.15
X6 Y A VGND VNB sky130_fd_pr__nfet_01v8 ad=0.08775 pd=0.92 as=0.247 ps=2.06 w=0.65 l=0.15
X7 Y A VGND VNB sky130_fd_pr__nfet_01v8 ad=0.08775 pd=0.92 as=0.08775 ps=0.92 w=0.65 l=0.15
X8 Y A VPWR VPB sky130_fd_pr__pfet_01v8_hvt ad=0.135 pd=1.27 as=0.43 ps=2.86 w=1 l=0.15
X9 VGND A Y VNB sky130_fd_pr__nfet_01v8 ad=0.08775 pd=0.92 as=0.08775 ps=0.92 w=0.65 l=0.15
X10 VGND A Y VNB sky130_fd_pr__nfet_01v8 ad=0.08775 pd=0.92 as=0.08775 ps=0.92 w=0.65 l=0.15
X11 VGND A Y VNB sky130_fd_pr__nfet_01v8 ad=0.1755 pd=1.84 as=0.08775 ps=0.92 w=0.65 l=0.15
.ends

.subckt sky130_fd_sc_hd__or4_1 VPWR VGND VPB VNB B D C A X
X0 a_27_297# B VGND VNB sky130_fd_pr__nfet_01v8 ad=0.0567 pd=0.69 as=0.0567 ps=0.69 w=0.42 l=0.15
X1 a_27_297# D VGND VNB sky130_fd_pr__nfet_01v8 ad=0.0693 pd=0.75 as=0.1092 ps=1.36 w=0.42 l=0.15
X2 a_277_297# B a_205_297# VPB sky130_fd_pr__pfet_01v8_hvt ad=0.0693 pd=0.75 as=0.0441 ps=0.63 w=0.42 l=0.15
X3 VPWR A a_277_297# VPB sky130_fd_pr__pfet_01v8_hvt ad=0.14825 pd=1.34 as=0.0693 ps=0.75 w=0.42 l=0.15
X4 X a_27_297# VGND VNB sky130_fd_pr__nfet_01v8 ad=0.1755 pd=1.84 as=0.10187 ps=0.99 w=0.65 l=0.15
X5 a_205_297# C a_109_297# VPB sky130_fd_pr__pfet_01v8_hvt ad=0.0441 pd=0.63 as=0.0693 ps=0.75 w=0.42 l=0.15
X6 X a_27_297# VPWR VPB sky130_fd_pr__pfet_01v8_hvt ad=0.27 pd=2.54 as=0.14825 ps=1.34 w=1 l=0.15
X7 VGND C a_27_297# VNB sky130_fd_pr__nfet_01v8 ad=0.0567 pd=0.69 as=0.0693 ps=0.75 w=0.42 l=0.15
X8 a_109_297# D a_27_297# VPB sky130_fd_pr__pfet_01v8_hvt ad=0.0693 pd=0.75 as=0.1092 ps=1.36 w=0.42 l=0.15
X9 VGND A a_27_297# VNB sky130_fd_pr__nfet_01v8 ad=0.10187 pd=0.99 as=0.0567 ps=0.69 w=0.42 l=0.15
.ends

.subckt sky130_fd_sc_hd__clkinv_4 VNB VPB VPWR VGND A Y
X0 Y A VPWR VPB sky130_fd_pr__pfet_01v8_hvt ad=0.14 pd=1.28 as=0.14 ps=1.28 w=1 l=0.15
X1 VGND A Y VNB sky130_fd_pr__nfet_01v8 ad=0.1659 pd=1.63 as=0.0588 ps=0.7 w=0.42 l=0.15
X2 VGND A Y VNB sky130_fd_pr__nfet_01v8 ad=0.0588 pd=0.7 as=0.0588 ps=0.7 w=0.42 l=0.15
X3 VPWR A Y VPB sky130_fd_pr__pfet_01v8_hvt ad=0.14 pd=1.28 as=0.14 ps=1.28 w=1 l=0.15
X4 VPWR A Y VPB sky130_fd_pr__pfet_01v8_hvt ad=0.345 pd=2.69 as=0.14 ps=1.28 w=1 l=0.15
X5 Y A VGND VNB sky130_fd_pr__nfet_01v8 ad=0.0588 pd=0.7 as=0.0588 ps=0.7 w=0.42 l=0.15
X6 Y A VPWR VPB sky130_fd_pr__pfet_01v8_hvt ad=0.14 pd=1.28 as=0.305 ps=2.61 w=1 l=0.15
X7 Y A VGND VNB sky130_fd_pr__nfet_01v8 ad=0.0588 pd=0.7 as=0.1386 ps=1.5 w=0.42 l=0.15
X8 Y A VPWR VPB sky130_fd_pr__pfet_01v8_hvt ad=0.14 pd=1.28 as=0.14 ps=1.28 w=1 l=0.15
X9 VPWR A Y VPB sky130_fd_pr__pfet_01v8_hvt ad=0.14 pd=1.28 as=0.14 ps=1.28 w=1 l=0.15
.ends

.subckt sky130_fd_sc_hd__nand3_1 VPB VNB VGND VPWR A B Y C
X0 VPWR B Y VPB sky130_fd_pr__pfet_01v8_hvt ad=0.165 pd=1.33 as=0.135 ps=1.27 w=1 l=0.15
X1 Y A VPWR VPB sky130_fd_pr__pfet_01v8_hvt ad=0.26 pd=2.52 as=0.165 ps=1.33 w=1 l=0.15
X2 a_193_47# B a_109_47# VNB sky130_fd_pr__nfet_01v8 ad=0.10725 pd=0.98 as=0.08775 ps=0.92 w=0.65 l=0.15
X3 Y A a_193_47# VNB sky130_fd_pr__nfet_01v8 ad=0.169 pd=1.82 as=0.10725 ps=0.98 w=0.65 l=0.15
X4 Y C VPWR VPB sky130_fd_pr__pfet_01v8_hvt ad=0.135 pd=1.27 as=0.26 ps=2.52 w=1 l=0.15
X5 a_109_47# C VGND VNB sky130_fd_pr__nfet_01v8 ad=0.08775 pd=0.92 as=0.169 ps=1.82 w=0.65 l=0.15
.ends

.subckt sky130_fd_sc_hd__nand4b_1 VPB VNB VGND VPWR Y C B D A_N
X0 Y B VPWR VPB sky130_fd_pr__pfet_01v8_hvt ad=0.195 pd=1.39 as=0.1925 ps=1.385 w=1 l=0.15
X1 a_232_47# D VGND VNB sky130_fd_pr__nfet_01v8 ad=0.08775 pd=0.92 as=0.11812 ps=1.04 w=0.65 l=0.15
X2 VPWR C Y VPB sky130_fd_pr__pfet_01v8_hvt ad=0.1925 pd=1.385 as=0.135 ps=1.27 w=1 l=0.15
X3 VPWR A_N a_41_93# VPB sky130_fd_pr__pfet_01v8_hvt ad=0.14575 pd=1.335 as=0.1092 ps=1.36 w=0.42 l=0.15
X4 VPWR a_41_93# Y VPB sky130_fd_pr__pfet_01v8_hvt ad=0.28 pd=2.56 as=0.195 ps=1.39 w=1 l=0.15
X5 a_316_47# C a_232_47# VNB sky130_fd_pr__nfet_01v8 ad=0.12513 pd=1.035 as=0.08775 ps=0.92 w=0.65 l=0.15
X6 Y a_41_93# a_423_47# VNB sky130_fd_pr__nfet_01v8 ad=0.2275 pd=2 as=0.12675 ps=1.04 w=0.65 l=0.15
X7 a_423_47# B a_316_47# VNB sky130_fd_pr__nfet_01v8 ad=0.12675 pd=1.04 as=0.12513 ps=1.035 w=0.65 l=0.15
X8 Y D VPWR VPB sky130_fd_pr__pfet_01v8_hvt ad=0.135 pd=1.27 as=0.14575 ps=1.335 w=1 l=0.15
X9 VGND A_N a_41_93# VNB sky130_fd_pr__nfet_01v8 ad=0.11812 pd=1.04 as=0.1113 ps=1.37 w=0.42 l=0.15
.ends

.subckt sky130_fd_sc_hd__clkinv_2 VNB VPB VPWR VGND A Y
X0 Y A VGND VNB sky130_fd_pr__nfet_01v8 ad=0.0588 pd=0.7 as=0.1113 ps=1.37 w=0.42 l=0.15
X1 Y A VPWR VPB sky130_fd_pr__pfet_01v8_hvt ad=0.14 pd=1.28 as=0.14 ps=1.28 w=1 l=0.15
X2 VPWR A Y VPB sky130_fd_pr__pfet_01v8_hvt ad=0.14 pd=1.28 as=0.265 ps=2.53 w=1 l=0.15
X3 VGND A Y VNB sky130_fd_pr__nfet_01v8 ad=0.1092 pd=1.36 as=0.0588 ps=0.7 w=0.42 l=0.15
X4 VPWR A Y VPB sky130_fd_pr__pfet_01v8_hvt ad=0.265 pd=2.53 as=0.14 ps=1.28 w=1 l=0.15
.ends

.subckt sky130_fd_sc_hd__o22ai_1 VPB VNB VGND VPWR A1 A2 B1 B2 Y
X0 VGND A2 a_27_47# VNB sky130_fd_pr__nfet_01v8 ad=0.08775 pd=0.92 as=0.11537 ps=1.005 w=0.65 l=0.15
X1 a_27_47# B2 Y VNB sky130_fd_pr__nfet_01v8 ad=0.11537 pd=1.005 as=0.09262 ps=0.935 w=0.65 l=0.15
X2 VPWR A1 a_307_297# VPB sky130_fd_pr__pfet_01v8_hvt ad=0.27 pd=2.54 as=0.105 ps=1.21 w=1 l=0.15
X3 a_307_297# A2 Y VPB sky130_fd_pr__pfet_01v8_hvt ad=0.105 pd=1.21 as=0.2325 ps=1.465 w=1 l=0.15
X4 a_27_47# A1 VGND VNB sky130_fd_pr__nfet_01v8 ad=0.169 pd=1.82 as=0.08775 ps=0.92 w=0.65 l=0.15
X5 Y B2 a_109_297# VPB sky130_fd_pr__pfet_01v8_hvt ad=0.2325 pd=1.465 as=0.1125 ps=1.225 w=1 l=0.15
X6 a_109_297# B1 VPWR VPB sky130_fd_pr__pfet_01v8_hvt ad=0.1125 pd=1.225 as=0.26 ps=2.52 w=1 l=0.15
X7 Y B1 a_27_47# VNB sky130_fd_pr__nfet_01v8 ad=0.09262 pd=0.935 as=0.169 ps=1.82 w=0.65 l=0.15
.ends

.subckt sky130_fd_sc_hd__clkinv_1 VPB VNB VGND VPWR A Y
X0 Y A VPWR VPB sky130_fd_pr__pfet_01v8_hvt ad=0.1134 pd=1.11 as=0.2184 ps=2.2 w=0.84 l=0.15
X1 VGND A Y VNB sky130_fd_pr__nfet_01v8 ad=0.1197 pd=1.41 as=0.1092 ps=1.36 w=0.42 l=0.15
X2 VPWR A Y VPB sky130_fd_pr__pfet_01v8_hvt ad=0.2352 pd=2.24 as=0.1134 ps=1.11 w=0.84 l=0.15
.ends

.subckt sky130_fd_sc_hd__nor4_1 VPB VNB VGND VPWR Y D C B A
X0 Y B VGND VNB sky130_fd_pr__nfet_01v8 ad=0.08775 pd=0.92 as=0.08937 ps=0.925 w=0.65 l=0.15
X1 a_191_297# C a_109_297# VPB sky130_fd_pr__pfet_01v8_hvt ad=0.19 pd=1.38 as=0.13 ps=1.26 w=1 l=0.15
X2 VPWR A a_297_297# VPB sky130_fd_pr__pfet_01v8_hvt ad=0.26 pd=2.52 as=0.135 ps=1.27 w=1 l=0.15
X3 VGND C Y VNB sky130_fd_pr__nfet_01v8 ad=0.08937 pd=0.925 as=0.11863 ps=1.015 w=0.65 l=0.15
X4 VGND A Y VNB sky130_fd_pr__nfet_01v8 ad=0.169 pd=1.82 as=0.08775 ps=0.92 w=0.65 l=0.15
X5 a_297_297# B a_191_297# VPB sky130_fd_pr__pfet_01v8_hvt ad=0.135 pd=1.27 as=0.19 ps=1.38 w=1 l=0.15
X6 a_109_297# D Y VPB sky130_fd_pr__pfet_01v8_hvt ad=0.13 pd=1.26 as=0.26 ps=2.52 w=1 l=0.15
X7 Y D VGND VNB sky130_fd_pr__nfet_01v8 ad=0.11863 pd=1.015 as=0.169 ps=1.82 w=0.65 l=0.15
.ends

.subckt sky130_fd_sc_hd__a211oi_1 VPWR VGND VPB VNB Y C1 B1 A1 A2
X0 a_56_297# A1 VPWR VPB sky130_fd_pr__pfet_01v8_hvt ad=0.14 pd=1.28 as=0.14 ps=1.28 w=1 l=0.15
X1 VPWR A2 a_56_297# VPB sky130_fd_pr__pfet_01v8_hvt ad=0.14 pd=1.28 as=0.265 ps=2.53 w=1 l=0.15
X2 Y C1 VGND VNB sky130_fd_pr__nfet_01v8 ad=0.17225 pd=1.83 as=0.10075 ps=0.96 w=0.65 l=0.15
X3 a_139_47# A2 VGND VNB sky130_fd_pr__nfet_01v8 ad=0.091 pd=0.93 as=0.2665 ps=2.12 w=0.65 l=0.15
X4 a_311_297# B1 a_56_297# VPB sky130_fd_pr__pfet_01v8_hvt ad=0.155 pd=1.31 as=0.14 ps=1.28 w=1 l=0.15
X5 Y C1 a_311_297# VPB sky130_fd_pr__pfet_01v8_hvt ad=0.265 pd=2.53 as=0.155 ps=1.31 w=1 l=0.15
X6 VGND B1 Y VNB sky130_fd_pr__nfet_01v8 ad=0.10075 pd=0.96 as=0.091 ps=0.93 w=0.65 l=0.15
X7 Y A1 a_139_47# VNB sky130_fd_pr__nfet_01v8 ad=0.091 pd=0.93 as=0.091 ps=0.93 w=0.65 l=0.15
.ends

.subckt sky130_fd_sc_hd__bufinv_16 VNB VPB VGND VPWR A Y
X0 a_361_47# a_27_47# VGND VNB sky130_fd_pr__nfet_01v8 ad=0.08775 pd=0.92 as=0.08775 ps=0.92 w=0.65 l=0.15
X1 VPWR a_361_47# Y VPB sky130_fd_pr__pfet_01v8_hvt ad=0.135 pd=1.27 as=0.135 ps=1.27 w=1 l=0.15
X2 a_361_47# a_27_47# VGND VNB sky130_fd_pr__nfet_01v8 ad=0.08775 pd=0.92 as=0.08775 ps=0.92 w=0.65 l=0.15
X3 Y a_361_47# VGND VNB sky130_fd_pr__nfet_01v8 ad=0.08775 pd=0.92 as=0.08775 ps=0.92 w=0.65 l=0.15
X4 VPWR a_361_47# Y VPB sky130_fd_pr__pfet_01v8_hvt ad=0.135 pd=1.27 as=0.135 ps=1.27 w=1 l=0.15
X5 Y a_361_47# VGND VNB sky130_fd_pr__nfet_01v8 ad=0.08775 pd=0.92 as=0.08775 ps=0.92 w=0.65 l=0.15
X6 Y a_361_47# VPWR VPB sky130_fd_pr__pfet_01v8_hvt ad=0.135 pd=1.27 as=0.135 ps=1.27 w=1 l=0.15
X7 VPWR a_27_47# a_361_47# VPB sky130_fd_pr__pfet_01v8_hvt ad=0.135 pd=1.27 as=0.135 ps=1.27 w=1 l=0.15
X8 VPWR a_361_47# Y VPB sky130_fd_pr__pfet_01v8_hvt ad=0.26 pd=2.52 as=0.135 ps=1.27 w=1 l=0.15
X9 VPWR a_361_47# Y VPB sky130_fd_pr__pfet_01v8_hvt ad=0.135 pd=1.27 as=0.135 ps=1.27 w=1 l=0.15
X10 VGND a_361_47# Y VNB sky130_fd_pr__nfet_01v8 ad=0.169 pd=1.82 as=0.08775 ps=0.92 w=0.65 l=0.15
X11 a_361_47# a_27_47# VPWR VPB sky130_fd_pr__pfet_01v8_hvt ad=0.135 pd=1.27 as=0.135 ps=1.27 w=1 l=0.15
X12 VGND a_361_47# Y VNB sky130_fd_pr__nfet_01v8 ad=0.08775 pd=0.92 as=0.08775 ps=0.92 w=0.65 l=0.15
X13 VGND a_361_47# Y VNB sky130_fd_pr__nfet_01v8 ad=0.08775 pd=0.92 as=0.08775 ps=0.92 w=0.65 l=0.15
X14 VGND a_361_47# Y VNB sky130_fd_pr__nfet_01v8 ad=0.08775 pd=0.92 as=0.08775 ps=0.92 w=0.65 l=0.15
X15 VGND a_361_47# Y VNB sky130_fd_pr__nfet_01v8 ad=0.08775 pd=0.92 as=0.08775 ps=0.92 w=0.65 l=0.15
X16 VPWR A a_27_47# VPB sky130_fd_pr__pfet_01v8_hvt ad=0.135 pd=1.27 as=0.135 ps=1.27 w=1 l=0.15
X17 Y a_361_47# VPWR VPB sky130_fd_pr__pfet_01v8_hvt ad=0.135 pd=1.27 as=0.135 ps=1.27 w=1 l=0.15
X18 VGND a_361_47# Y VNB sky130_fd_pr__nfet_01v8 ad=0.08775 pd=0.92 as=0.08775 ps=0.92 w=0.65 l=0.15
X19 VPWR a_361_47# Y VPB sky130_fd_pr__pfet_01v8_hvt ad=0.135 pd=1.27 as=0.135 ps=1.27 w=1 l=0.15
X20 a_27_47# A VPWR VPB sky130_fd_pr__pfet_01v8_hvt ad=0.135 pd=1.27 as=0.135 ps=1.27 w=1 l=0.15
X21 Y a_361_47# VPWR VPB sky130_fd_pr__pfet_01v8_hvt ad=0.135 pd=1.27 as=0.135 ps=1.27 w=1 l=0.15
X22 a_27_47# A VGND VNB sky130_fd_pr__nfet_01v8 ad=0.08775 pd=0.92 as=0.08775 ps=0.92 w=0.65 l=0.15
X23 a_361_47# a_27_47# VGND VNB sky130_fd_pr__nfet_01v8 ad=0.08775 pd=0.92 as=0.08775 ps=0.92 w=0.65 l=0.15
X24 Y a_361_47# VPWR VPB sky130_fd_pr__pfet_01v8_hvt ad=0.135 pd=1.27 as=0.135 ps=1.27 w=1 l=0.15
X25 Y a_361_47# VGND VNB sky130_fd_pr__nfet_01v8 ad=0.08775 pd=0.92 as=0.08775 ps=0.92 w=0.65 l=0.15
X26 VPWR a_27_47# a_361_47# VPB sky130_fd_pr__pfet_01v8_hvt ad=0.135 pd=1.27 as=0.135 ps=1.27 w=1 l=0.15
X27 Y a_361_47# VGND VNB sky130_fd_pr__nfet_01v8 ad=0.08775 pd=0.92 as=0.08775 ps=0.92 w=0.65 l=0.15
X28 Y a_361_47# VPWR VPB sky130_fd_pr__pfet_01v8_hvt ad=0.135 pd=1.27 as=0.135 ps=1.27 w=1 l=0.15
X29 Y a_361_47# VGND VNB sky130_fd_pr__nfet_01v8 ad=0.08775 pd=0.92 as=0.08775 ps=0.92 w=0.65 l=0.15
X30 a_361_47# a_27_47# VPWR VPB sky130_fd_pr__pfet_01v8_hvt ad=0.135 pd=1.27 as=0.135 ps=1.27 w=1 l=0.15
X31 VPWR a_361_47# Y VPB sky130_fd_pr__pfet_01v8_hvt ad=0.135 pd=1.27 as=0.135 ps=1.27 w=1 l=0.15
X32 Y a_361_47# VGND VNB sky130_fd_pr__nfet_01v8 ad=0.08775 pd=0.92 as=0.08775 ps=0.92 w=0.65 l=0.15
X33 VGND A a_27_47# VNB sky130_fd_pr__nfet_01v8 ad=0.08775 pd=0.92 as=0.08775 ps=0.92 w=0.65 l=0.15
X34 VGND a_27_47# a_361_47# VNB sky130_fd_pr__nfet_01v8 ad=0.08775 pd=0.92 as=0.08775 ps=0.92 w=0.65 l=0.15
X35 VPWR a_27_47# a_361_47# VPB sky130_fd_pr__pfet_01v8_hvt ad=0.135 pd=1.27 as=0.135 ps=1.27 w=1 l=0.15
X36 Y a_361_47# VPWR VPB sky130_fd_pr__pfet_01v8_hvt ad=0.135 pd=1.27 as=0.135 ps=1.27 w=1 l=0.15
X37 VGND a_27_47# a_361_47# VNB sky130_fd_pr__nfet_01v8 ad=0.08775 pd=0.92 as=0.08775 ps=0.92 w=0.65 l=0.15
X38 VGND a_27_47# a_361_47# VNB sky130_fd_pr__nfet_01v8 ad=0.08775 pd=0.92 as=0.08775 ps=0.92 w=0.65 l=0.15
X39 a_361_47# a_27_47# VPWR VPB sky130_fd_pr__pfet_01v8_hvt ad=0.135 pd=1.27 as=0.135 ps=1.27 w=1 l=0.15
X40 VPWR a_361_47# Y VPB sky130_fd_pr__pfet_01v8_hvt ad=0.135 pd=1.27 as=0.135 ps=1.27 w=1 l=0.15
X41 VPWR a_361_47# Y VPB sky130_fd_pr__pfet_01v8_hvt ad=0.135 pd=1.27 as=0.135 ps=1.27 w=1 l=0.15
X42 VGND a_361_47# Y VNB sky130_fd_pr__nfet_01v8 ad=0.08775 pd=0.92 as=0.08775 ps=0.92 w=0.65 l=0.15
X43 VGND a_361_47# Y VNB sky130_fd_pr__nfet_01v8 ad=0.08775 pd=0.92 as=0.08775 ps=0.92 w=0.65 l=0.15
X44 VPWR A a_27_47# VPB sky130_fd_pr__pfet_01v8_hvt ad=0.135 pd=1.27 as=0.26 ps=2.52 w=1 l=0.15
X45 Y a_361_47# VPWR VPB sky130_fd_pr__pfet_01v8_hvt ad=0.135 pd=1.27 as=0.135 ps=1.27 w=1 l=0.15
X46 Y a_361_47# VGND VNB sky130_fd_pr__nfet_01v8 ad=0.08775 pd=0.92 as=0.08775 ps=0.92 w=0.65 l=0.15
X47 Y a_361_47# VPWR VPB sky130_fd_pr__pfet_01v8_hvt ad=0.135 pd=1.27 as=0.135 ps=1.27 w=1 l=0.15
X48 VGND A a_27_47# VNB sky130_fd_pr__nfet_01v8 ad=0.08775 pd=0.92 as=0.169 ps=1.82 w=0.65 l=0.15
X49 Y a_361_47# VGND VNB sky130_fd_pr__nfet_01v8 ad=0.08775 pd=0.92 as=0.08775 ps=0.92 w=0.65 l=0.15
.ends

.subckt sky130_fd_sc_hd__or2_0 VNB VPB VGND VPWR B A X
X0 VGND A a_68_355# VNB sky130_fd_pr__nfet_01v8 ad=0.07035 pd=0.755 as=0.0567 ps=0.69 w=0.42 l=0.15
X1 a_150_355# B a_68_355# VPB sky130_fd_pr__pfet_01v8_hvt ad=0.0441 pd=0.63 as=0.1092 ps=1.36 w=0.42 l=0.15
X2 a_68_355# B VGND VNB sky130_fd_pr__nfet_01v8 ad=0.0567 pd=0.69 as=0.1092 ps=1.36 w=0.42 l=0.15
X3 X a_68_355# VGND VNB sky130_fd_pr__nfet_01v8 ad=0.1092 pd=1.36 as=0.07035 ps=0.755 w=0.42 l=0.15
X4 VPWR A a_150_355# VPB sky130_fd_pr__pfet_01v8_hvt ad=0.09895 pd=0.975 as=0.0441 ps=0.63 w=0.42 l=0.15
X5 X a_68_355# VPWR VPB sky130_fd_pr__pfet_01v8_hvt ad=0.2176 pd=1.96 as=0.09895 ps=0.975 w=0.64 l=0.15
.ends

.subckt sky130_fd_sc_hd__nor3_1 VPB VNB VGND VPWR C B A Y
X0 VPWR A a_193_297# VPB sky130_fd_pr__pfet_01v8_hvt ad=0.26 pd=2.52 as=0.135 ps=1.27 w=1 l=0.15
X1 a_193_297# B a_109_297# VPB sky130_fd_pr__pfet_01v8_hvt ad=0.135 pd=1.27 as=0.135 ps=1.27 w=1 l=0.15
X2 Y B VGND VNB sky130_fd_pr__nfet_01v8 ad=0.08775 pd=0.92 as=0.08775 ps=0.92 w=0.65 l=0.15
X3 VGND A Y VNB sky130_fd_pr__nfet_01v8 ad=0.169 pd=1.82 as=0.08775 ps=0.92 w=0.65 l=0.15
X4 a_109_297# C Y VPB sky130_fd_pr__pfet_01v8_hvt ad=0.135 pd=1.27 as=0.26 ps=2.52 w=1 l=0.15
X5 VGND C Y VNB sky130_fd_pr__nfet_01v8 ad=0.08775 pd=0.92 as=0.169 ps=1.82 w=0.65 l=0.15
.ends

.subckt sky130_fd_sc_hd__clkinvlp_4 VNB VPB VPWR VGND A Y
X0 Y A VPWR VPB sky130_fd_pr__pfet_01v8_hvt ad=0.14 pd=1.28 as=0.265 ps=2.53 w=1 l=0.25
X1 VGND A a_268_47# VNB sky130_fd_pr__nfet_01v8 ad=0.14575 pd=1.63 as=0.05775 ps=0.76 w=0.55 l=0.15
X2 Y A VPWR VPB sky130_fd_pr__pfet_01v8_hvt ad=0.14 pd=1.28 as=0.14 ps=1.28 w=1 l=0.25
X3 Y A a_110_47# VNB sky130_fd_pr__nfet_01v8 ad=0.077 pd=0.83 as=0.05775 ps=0.76 w=0.55 l=0.15
X4 VPWR A Y VPB sky130_fd_pr__pfet_01v8_hvt ad=0.14 pd=1.28 as=0.14 ps=1.28 w=1 l=0.25
X5 a_110_47# A VGND VNB sky130_fd_pr__nfet_01v8 ad=0.05775 pd=0.76 as=0.14575 ps=1.63 w=0.55 l=0.15
X6 a_268_47# A Y VNB sky130_fd_pr__nfet_01v8 ad=0.05775 pd=0.76 as=0.077 ps=0.83 w=0.55 l=0.15
X7 VPWR A Y VPB sky130_fd_pr__pfet_01v8_hvt ad=0.265 pd=2.53 as=0.14 ps=1.28 w=1 l=0.25
.ends

.subckt sky130_fd_sc_hd__nand3b_1 VPB VNB VGND VPWR Y B C A_N
X0 Y a_53_93# VPWR VPB sky130_fd_pr__pfet_01v8_hvt ad=0.28 pd=2.56 as=0.1925 ps=1.385 w=1 l=0.15
X1 a_232_47# C VGND VNB sky130_fd_pr__nfet_01v8 ad=0.08775 pd=0.92 as=0.10025 ps=0.985 w=0.65 l=0.15
X2 VPWR B Y VPB sky130_fd_pr__pfet_01v8_hvt ad=0.1925 pd=1.385 as=0.135 ps=1.27 w=1 l=0.15
X3 VPWR A_N a_53_93# VPB sky130_fd_pr__pfet_01v8_hvt ad=0.14575 pd=1.335 as=0.1092 ps=1.36 w=0.42 l=0.15
X4 VGND A_N a_53_93# VNB sky130_fd_pr__nfet_01v8 ad=0.10025 pd=0.985 as=0.1092 ps=1.36 w=0.42 l=0.15
X5 a_316_47# B a_232_47# VNB sky130_fd_pr__nfet_01v8 ad=0.12513 pd=1.035 as=0.08775 ps=0.92 w=0.65 l=0.15
X6 Y a_53_93# a_316_47# VNB sky130_fd_pr__nfet_01v8 ad=0.182 pd=1.86 as=0.12513 ps=1.035 w=0.65 l=0.15
X7 Y C VPWR VPB sky130_fd_pr__pfet_01v8_hvt ad=0.135 pd=1.27 as=0.14575 ps=1.335 w=1 l=0.15
.ends

.subckt sky130_fd_sc_hd__o31ai_1 VPB VNB A1 A2 A3 Y B1 VPWR VGND
X0 Y B1 a_109_47# VNB sky130_fd_pr__nfet_01v8 ad=0.221 pd=1.98 as=0.19825 ps=1.26 w=0.65 l=0.15
X1 Y A3 a_193_297# VPB sky130_fd_pr__pfet_01v8_hvt ad=0.3925 pd=1.785 as=0.135 ps=1.27 w=1 l=0.15
X2 a_193_297# A2 a_109_297# VPB sky130_fd_pr__pfet_01v8_hvt ad=0.135 pd=1.27 as=0.135 ps=1.27 w=1 l=0.15
X3 VGND A2 a_109_47# VNB sky130_fd_pr__nfet_01v8 ad=0.08775 pd=0.92 as=0.08775 ps=0.92 w=0.65 l=0.15
X4 VPWR B1 Y VPB sky130_fd_pr__pfet_01v8_hvt ad=0.3 pd=2.6 as=0.3925 ps=1.785 w=1 l=0.15
X5 a_109_47# A3 VGND VNB sky130_fd_pr__nfet_01v8 ad=0.19825 pd=1.26 as=0.08775 ps=0.92 w=0.65 l=0.15
X6 a_109_297# A1 VPWR VPB sky130_fd_pr__pfet_01v8_hvt ad=0.135 pd=1.27 as=0.26 ps=2.52 w=1 l=0.15
X7 a_109_47# A1 VGND VNB sky130_fd_pr__nfet_01v8 ad=0.08775 pd=0.92 as=0.169 ps=1.82 w=0.65 l=0.15
.ends

.subckt sky130_fd_sc_hd__nor3b_2 VPB VNB VGND VPWR A Y C_N B
X0 a_281_297# B a_27_297# VPB sky130_fd_pr__pfet_01v8_hvt ad=0.135 pd=1.27 as=0.135 ps=1.27 w=1 l=0.15
X1 Y B VGND VNB sky130_fd_pr__nfet_01v8 ad=0.08775 pd=0.92 as=0.08775 ps=0.92 w=0.65 l=0.15
X2 a_27_297# A VPWR VPB sky130_fd_pr__pfet_01v8_hvt ad=0.135 pd=1.27 as=0.135 ps=1.27 w=1 l=0.15
X3 VGND a_531_21# Y VNB sky130_fd_pr__nfet_01v8 ad=0.182 pd=1.86 as=0.08775 ps=0.92 w=0.65 l=0.15
X4 VPWR C_N a_531_21# VPB sky130_fd_pr__pfet_01v8_hvt ad=0.1092 pd=1.36 as=0.1092 ps=1.36 w=0.42 l=0.15
X5 VGND A Y VNB sky130_fd_pr__nfet_01v8 ad=0.08775 pd=0.92 as=0.08775 ps=0.92 w=0.65 l=0.15
X6 Y A VGND VNB sky130_fd_pr__nfet_01v8 ad=0.08775 pd=0.92 as=0.182 ps=1.86 w=0.65 l=0.15
X7 VGND B Y VNB sky130_fd_pr__nfet_01v8 ad=0.169 pd=1.82 as=0.08775 ps=0.92 w=0.65 l=0.15
X8 VPWR A a_27_297# VPB sky130_fd_pr__pfet_01v8_hvt ad=0.135 pd=1.27 as=0.28 ps=2.56 w=1 l=0.15
X9 a_281_297# a_531_21# Y VPB sky130_fd_pr__pfet_01v8_hvt ad=0.28 pd=2.56 as=0.135 ps=1.27 w=1 l=0.15
X10 Y a_531_21# a_281_297# VPB sky130_fd_pr__pfet_01v8_hvt ad=0.135 pd=1.27 as=0.28 ps=2.56 w=1 l=0.15
X11 VGND C_N a_531_21# VNB sky130_fd_pr__nfet_01v8 ad=0.1092 pd=1.36 as=0.1092 ps=1.36 w=0.42 l=0.15
X12 a_27_297# B a_281_297# VPB sky130_fd_pr__pfet_01v8_hvt ad=0.28 pd=2.56 as=0.135 ps=1.27 w=1 l=0.15
X13 Y a_531_21# VGND VNB sky130_fd_pr__nfet_01v8 ad=0.08775 pd=0.92 as=0.169 ps=1.82 w=0.65 l=0.15
.ends

.subckt sky130_fd_sc_hd__or2_1 VPB VNB VGND VPWR X A B
X0 VGND A a_68_297# VNB sky130_fd_pr__nfet_01v8 ad=0.10025 pd=0.985 as=0.0567 ps=0.69 w=0.42 l=0.15
X1 a_68_297# B VGND VNB sky130_fd_pr__nfet_01v8 ad=0.0567 pd=0.69 as=0.1092 ps=1.36 w=0.42 l=0.15
X2 X a_68_297# VGND VNB sky130_fd_pr__nfet_01v8 ad=0.169 pd=1.82 as=0.10025 ps=0.985 w=0.65 l=0.15
X3 VPWR A a_150_297# VPB sky130_fd_pr__pfet_01v8_hvt ad=0.14575 pd=1.335 as=0.0441 ps=0.63 w=0.42 l=0.15
X4 X a_68_297# VPWR VPB sky130_fd_pr__pfet_01v8_hvt ad=0.34 pd=2.68 as=0.14575 ps=1.335 w=1 l=0.15
X5 a_150_297# B a_68_297# VPB sky130_fd_pr__pfet_01v8_hvt ad=0.0441 pd=0.63 as=0.1092 ps=1.36 w=0.42 l=0.15
.ends

.subckt sky130_fd_sc_hd__and2_1 VPWR VGND X B A VPB VNB
X0 VPWR B a_59_75# VPB sky130_fd_pr__pfet_01v8_hvt ad=0.16655 pd=1.39 as=0.0567 ps=0.69 w=0.42 l=0.15
X1 X a_59_75# VPWR VPB sky130_fd_pr__pfet_01v8_hvt ad=0.475 pd=2.95 as=0.16655 ps=1.39 w=1 l=0.15
X2 VGND B a_145_75# VNB sky130_fd_pr__nfet_01v8 ad=0.1118 pd=1.04 as=0.0567 ps=0.69 w=0.42 l=0.15
X3 a_59_75# A VPWR VPB sky130_fd_pr__pfet_01v8_hvt ad=0.0567 pd=0.69 as=0.1176 ps=1.4 w=0.42 l=0.15
X4 X a_59_75# VGND VNB sky130_fd_pr__nfet_01v8 ad=0.182 pd=1.86 as=0.1118 ps=1.04 w=0.65 l=0.15
X5 a_145_75# A a_59_75# VNB sky130_fd_pr__nfet_01v8 ad=0.0567 pd=0.69 as=0.1176 ps=1.4 w=0.42 l=0.15
.ends

.subckt sky130_fd_sc_hd__clkinvlp_2 VGND VPWR A Y VPB VNB
X0 Y A a_150_67# VNB sky130_fd_pr__nfet_01v8 ad=0.15675 pd=1.67 as=0.066 ps=0.79 w=0.55 l=0.15
X1 VPWR A Y VPB sky130_fd_pr__pfet_01v8_hvt ad=0.39 pd=2.78 as=0.14 ps=1.28 w=1 l=0.25
X2 a_150_67# A VGND VNB sky130_fd_pr__nfet_01v8 ad=0.066 pd=0.79 as=0.15675 ps=1.67 w=0.55 l=0.15
X3 Y A VPWR VPB sky130_fd_pr__pfet_01v8_hvt ad=0.14 pd=1.28 as=0.265 ps=2.53 w=1 l=0.25
.ends

.subckt sky130_fd_sc_hd__a221o_1 VPWR VGND VPB VNB A1 A2 X B1 B2 C1
X0 a_465_47# A1 a_27_47# VNB sky130_fd_pr__nfet_01v8 ad=0.10725 pd=0.98 as=0.169 ps=1.82 w=0.65 l=0.15
X1 X a_27_47# VPWR VPB sky130_fd_pr__pfet_01v8_hvt ad=0.26 pd=2.52 as=0.1575 ps=1.315 w=1 l=0.15
X2 a_109_297# B1 a_193_297# VPB sky130_fd_pr__pfet_01v8_hvt ad=0.26 pd=2.52 as=0.135 ps=1.27 w=1 l=0.15
X3 a_193_297# B2 a_109_297# VPB sky130_fd_pr__pfet_01v8_hvt ad=0.135 pd=1.27 as=0.135 ps=1.27 w=1 l=0.15
X4 X a_27_47# VGND VNB sky130_fd_pr__nfet_01v8 ad=0.169 pd=1.82 as=0.10238 ps=0.965 w=0.65 l=0.15
X5 a_205_47# B2 VGND VNB sky130_fd_pr__nfet_01v8 ad=0.06825 pd=0.86 as=0.10725 ps=0.98 w=0.65 l=0.15
X6 VPWR A2 a_193_297# VPB sky130_fd_pr__pfet_01v8_hvt ad=0.1575 pd=1.315 as=0.165 ps=1.33 w=1 l=0.15
X7 a_193_297# A1 VPWR VPB sky130_fd_pr__pfet_01v8_hvt ad=0.165 pd=1.33 as=0.26 ps=2.52 w=1 l=0.15
X8 a_27_47# B1 a_205_47# VNB sky130_fd_pr__nfet_01v8 ad=0.169 pd=1.82 as=0.06825 ps=0.86 w=0.65 l=0.15
X9 a_109_297# C1 a_27_47# VPB sky130_fd_pr__pfet_01v8_hvt ad=0.135 pd=1.27 as=0.26 ps=2.52 w=1 l=0.15
X10 VGND C1 a_27_47# VNB sky130_fd_pr__nfet_01v8 ad=0.10725 pd=0.98 as=0.169 ps=1.82 w=0.65 l=0.15
X11 VGND A2 a_465_47# VNB sky130_fd_pr__nfet_01v8 ad=0.10238 pd=0.965 as=0.10725 ps=0.98 w=0.65 l=0.15
.ends

.subckt sky130_fd_sc_hd__or3_2 VGND VPWR VPB VNB B C A X
X0 VPWR a_30_53# X VPB sky130_fd_pr__pfet_01v8_hvt ad=0.315 pd=2.63 as=0.135 ps=1.27 w=1 l=0.15
X1 VGND a_30_53# X VNB sky130_fd_pr__nfet_01v8 ad=0.18525 pd=1.87 as=0.08775 ps=0.92 w=0.65 l=0.15
X2 X a_30_53# VPWR VPB sky130_fd_pr__pfet_01v8_hvt ad=0.135 pd=1.27 as=0.14825 ps=1.34 w=1 l=0.15
X3 a_112_297# C a_30_53# VPB sky130_fd_pr__pfet_01v8_hvt ad=0.0441 pd=0.63 as=0.1092 ps=1.36 w=0.42 l=0.15
X4 X a_30_53# VGND VNB sky130_fd_pr__nfet_01v8 ad=0.08775 pd=0.92 as=0.10187 ps=0.99 w=0.65 l=0.15
X5 VGND A a_30_53# VNB sky130_fd_pr__nfet_01v8 ad=0.10187 pd=0.99 as=0.0567 ps=0.69 w=0.42 l=0.15
X6 a_30_53# B VGND VNB sky130_fd_pr__nfet_01v8 ad=0.0567 pd=0.69 as=0.0567 ps=0.69 w=0.42 l=0.15
X7 VGND C a_30_53# VNB sky130_fd_pr__nfet_01v8 ad=0.0567 pd=0.69 as=0.1092 ps=1.36 w=0.42 l=0.15
X8 a_184_297# B a_112_297# VPB sky130_fd_pr__pfet_01v8_hvt ad=0.0693 pd=0.75 as=0.0441 ps=0.63 w=0.42 l=0.15
X9 VPWR A a_184_297# VPB sky130_fd_pr__pfet_01v8_hvt ad=0.14825 pd=1.34 as=0.0693 ps=0.75 w=0.42 l=0.15
.ends

.subckt sky130_fd_sc_hd__a21oi_2 VNB VPB VGND VPWR A2 A1 Y B1
X0 VGND A2 a_285_47# VNB sky130_fd_pr__nfet_01v8 ad=0.10725 pd=0.98 as=0.06825 ps=0.86 w=0.65 l=0.15
X1 VGND B1 Y VNB sky130_fd_pr__nfet_01v8 ad=0.26 pd=2.1 as=0.08775 ps=0.92 w=0.65 l=0.15
X2 Y A1 a_114_47# VNB sky130_fd_pr__nfet_01v8 ad=0.091 pd=0.93 as=0.08937 ps=0.925 w=0.65 l=0.15
X3 a_114_47# A2 VGND VNB sky130_fd_pr__nfet_01v8 ad=0.08937 pd=0.925 as=0.18525 ps=1.87 w=0.65 l=0.15
X4 a_27_297# B1 Y VPB sky130_fd_pr__pfet_01v8_hvt ad=0.36 pd=2.72 as=0.135 ps=1.27 w=1 l=0.15
X5 a_27_297# A1 VPWR VPB sky130_fd_pr__pfet_01v8_hvt ad=0.14 pd=1.28 as=0.14 ps=1.28 w=1 l=0.15
X6 Y B1 a_27_297# VPB sky130_fd_pr__pfet_01v8_hvt ad=0.135 pd=1.27 as=0.135 ps=1.27 w=1 l=0.15
X7 VPWR A2 a_27_297# VPB sky130_fd_pr__pfet_01v8_hvt ad=0.14 pd=1.28 as=0.28 ps=2.56 w=1 l=0.15
X8 a_27_297# A2 VPWR VPB sky130_fd_pr__pfet_01v8_hvt ad=0.135 pd=1.27 as=0.135 ps=1.27 w=1 l=0.15
X9 VPWR A1 a_27_297# VPB sky130_fd_pr__pfet_01v8_hvt ad=0.135 pd=1.27 as=0.14 ps=1.28 w=1 l=0.15
X10 a_285_47# A1 Y VNB sky130_fd_pr__nfet_01v8 ad=0.06825 pd=0.86 as=0.091 ps=0.93 w=0.65 l=0.15
X11 Y B1 VGND VNB sky130_fd_pr__nfet_01v8 ad=0.08775 pd=0.92 as=0.10725 ps=0.98 w=0.65 l=0.15
.ends

.subckt sky130_fd_sc_hd__o211a_2 VNB VPB VPWR VGND A2 A1 X C1 B1
X0 a_27_47# B1 VPWR VPB sky130_fd_pr__pfet_01v8_hvt ad=0.3675 pd=1.735 as=0.14 ps=1.28 w=1 l=0.15
X1 VGND a_27_47# X VNB sky130_fd_pr__nfet_01v8 ad=0.23075 pd=2.01 as=0.091 ps=0.93 w=0.65 l=0.15
X2 VPWR C1 a_27_47# VPB sky130_fd_pr__pfet_01v8_hvt ad=0.14 pd=1.28 as=0.265 ps=2.53 w=1 l=0.15
X3 VPWR A1 a_373_297# VPB sky130_fd_pr__pfet_01v8_hvt ad=0.195 pd=1.39 as=0.105 ps=1.21 w=1 l=0.15
X4 a_182_47# A2 VGND VNB sky130_fd_pr__nfet_01v8 ad=0.091 pd=0.93 as=0.16535 ps=1.82 w=0.65 l=0.15
X5 X a_27_47# VPWR VPB sky130_fd_pr__pfet_01v8_hvt ad=0.14 pd=1.28 as=0.195 ps=1.39 w=1 l=0.15
X6 a_182_47# B1 a_110_47# VNB sky130_fd_pr__nfet_01v8 ad=0.16535 pd=1.82 as=0.06825 ps=0.86 w=0.65 l=0.15
X7 X a_27_47# VGND VNB sky130_fd_pr__nfet_01v8 ad=0.091 pd=0.93 as=0.104 ps=0.97 w=0.65 l=0.15
X8 a_373_297# A2 a_27_47# VPB sky130_fd_pr__pfet_01v8_hvt ad=0.105 pd=1.21 as=0.3675 ps=1.735 w=1 l=0.15
X9 a_110_47# C1 a_27_47# VNB sky130_fd_pr__nfet_01v8 ad=0.06825 pd=0.86 as=0.17225 ps=1.83 w=0.65 l=0.15
X10 VPWR a_27_47# X VPB sky130_fd_pr__pfet_01v8_hvt ad=0.265 pd=2.53 as=0.14 ps=1.28 w=1 l=0.15
X11 VGND A1 a_182_47# VNB sky130_fd_pr__nfet_01v8 ad=0.104 pd=0.97 as=0.091 ps=0.93 w=0.65 l=0.15
.ends

.subckt sky130_fd_sc_hd__a2111oi_2 VNB VPB VGND VPWR A1 A2 D1 C1 B1 Y
X0 a_467_297# B1 a_28_297# VPB sky130_fd_pr__pfet_01v8_hvt ad=0.14 pd=1.28 as=0.16 ps=1.32 w=1 l=0.15
X1 a_287_297# D1 Y VPB sky130_fd_pr__pfet_01v8_hvt ad=0.14 pd=1.28 as=0.14 ps=1.28 w=1 l=0.15
X2 VPWR A2 a_467_297# VPB sky130_fd_pr__pfet_01v8_hvt ad=0.16 pd=1.32 as=0.14 ps=1.28 w=1 l=0.15
X3 a_923_47# A2 VGND VNB sky130_fd_pr__nfet_01v8 ad=0.091 pd=0.93 as=0.11213 ps=0.995 w=0.65 l=0.15
X4 Y B1 VGND VNB sky130_fd_pr__nfet_01v8 ad=0.091 pd=0.93 as=0.12675 ps=1.04 w=0.65 l=0.15
X5 a_28_297# B1 a_467_297# VPB sky130_fd_pr__pfet_01v8_hvt ad=0.26 pd=2.52 as=0.14 ps=1.28 w=1 l=0.15
X6 VGND C1 Y VNB sky130_fd_pr__nfet_01v8 ad=0.091 pd=0.93 as=0.18525 ps=1.87 w=0.65 l=0.15
X7 a_28_297# C1 a_287_297# VPB sky130_fd_pr__pfet_01v8_hvt ad=0.16 pd=1.32 as=0.14 ps=1.28 w=1 l=0.15
X8 Y A1 a_923_47# VNB sky130_fd_pr__nfet_01v8 ad=0.17225 pd=1.83 as=0.091 ps=0.93 w=0.65 l=0.15
X9 VGND A2 a_684_47# VNB sky130_fd_pr__nfet_01v8 ad=0.11213 pd=0.995 as=0.17875 ps=1.2 w=0.65 l=0.15
X10 Y D1 VGND VNB sky130_fd_pr__nfet_01v8 ad=0.091 pd=0.93 as=0.091 ps=0.93 w=0.65 l=0.15
X11 VGND B1 Y VNB sky130_fd_pr__nfet_01v8 ad=0.12675 pd=1.04 as=0.10563 ps=0.975 w=0.65 l=0.15
X12 Y D1 a_115_297# VPB sky130_fd_pr__pfet_01v8_hvt ad=0.14 pd=1.28 as=0.14 ps=1.28 w=1 l=0.15
X13 a_467_297# A1 VPWR VPB sky130_fd_pr__pfet_01v8_hvt ad=0.335 pd=2.67 as=0.16 ps=1.32 w=1 l=0.15
X14 VGND D1 Y VNB sky130_fd_pr__nfet_01v8 ad=0.12675 pd=1.04 as=0.091 ps=0.93 w=0.65 l=0.15
X15 Y C1 VGND VNB sky130_fd_pr__nfet_01v8 ad=0.10563 pd=0.975 as=0.12675 ps=1.04 w=0.65 l=0.15
X16 VPWR A1 a_467_297# VPB sky130_fd_pr__pfet_01v8_hvt ad=0.14 pd=1.28 as=0.26 ps=2.52 w=1 l=0.15
X17 a_115_297# C1 a_28_297# VPB sky130_fd_pr__pfet_01v8_hvt ad=0.14 pd=1.28 as=0.285 ps=2.57 w=1 l=0.15
X18 a_467_297# A2 VPWR VPB sky130_fd_pr__pfet_01v8_hvt ad=0.14 pd=1.28 as=0.14 ps=1.28 w=1 l=0.15
X19 a_684_47# A1 Y VNB sky130_fd_pr__nfet_01v8 ad=0.17875 pd=1.2 as=0.091 ps=0.93 w=0.65 l=0.15
.ends

.subckt sky130_fd_sc_hd__o31ai_2 VGND VPWR VPB VNB Y A3 A2 A1 B1
X0 a_281_297# A3 Y VPB sky130_fd_pr__pfet_01v8_hvt ad=0.135 pd=1.27 as=0.28 ps=2.56 w=1 l=0.15
X1 a_281_297# A2 a_27_297# VPB sky130_fd_pr__pfet_01v8_hvt ad=0.135 pd=1.27 as=0.135 ps=1.27 w=1 l=0.15
X2 VGND A2 a_27_47# VNB sky130_fd_pr__nfet_01v8 ad=0.19825 pd=1.26 as=0.08775 ps=0.92 w=0.65 l=0.15
X3 a_27_297# A1 VPWR VPB sky130_fd_pr__pfet_01v8_hvt ad=0.135 pd=1.27 as=0.135 ps=1.27 w=1 l=0.15
X4 a_27_47# A1 VGND VNB sky130_fd_pr__nfet_01v8 ad=0.08775 pd=0.92 as=0.08775 ps=0.92 w=0.65 l=0.15
X5 VGND A1 a_27_47# VNB sky130_fd_pr__nfet_01v8 ad=0.08775 pd=0.92 as=0.182 ps=1.86 w=0.65 l=0.15
X6 a_27_47# A3 VGND VNB sky130_fd_pr__nfet_01v8 ad=0.08775 pd=0.92 as=0.11375 ps=1 w=0.65 l=0.15
X7 VPWR B1 Y VPB sky130_fd_pr__pfet_01v8_hvt ad=0.195 pd=1.39 as=0.135 ps=1.27 w=1 l=0.15
X8 VPWR A1 a_27_297# VPB sky130_fd_pr__pfet_01v8_hvt ad=0.135 pd=1.27 as=0.28 ps=2.56 w=1 l=0.15
X9 a_27_47# B1 Y VNB sky130_fd_pr__nfet_01v8 ad=0.169 pd=1.82 as=0.12675 ps=1.04 w=0.65 l=0.15
X10 a_27_47# A2 VGND VNB sky130_fd_pr__nfet_01v8 ad=0.12675 pd=1.04 as=0.19825 ps=1.26 w=0.65 l=0.15
X11 VGND A3 a_27_47# VNB sky130_fd_pr__nfet_01v8 ad=0.11375 pd=1 as=0.12675 ps=1.04 w=0.65 l=0.15
X12 Y B1 a_27_47# VNB sky130_fd_pr__nfet_01v8 ad=0.12675 pd=1.04 as=0.08775 ps=0.92 w=0.65 l=0.15
X13 Y A3 a_281_297# VPB sky130_fd_pr__pfet_01v8_hvt ad=0.135 pd=1.27 as=0.135 ps=1.27 w=1 l=0.15
X14 Y B1 VPWR VPB sky130_fd_pr__pfet_01v8_hvt ad=0.26 pd=2.52 as=0.195 ps=1.39 w=1 l=0.15
X15 a_27_297# A2 a_281_297# VPB sky130_fd_pr__pfet_01v8_hvt ad=0.26 pd=2.52 as=0.135 ps=1.27 w=1 l=0.15
.ends

.subckt sky130_fd_sc_hd__nand2_2 VPB VNB VGND VPWR Y A B
X0 VPWR A Y VPB sky130_fd_pr__pfet_01v8_hvt ad=0.26 pd=2.52 as=0.135 ps=1.27 w=1 l=0.15
X1 Y A VPWR VPB sky130_fd_pr__pfet_01v8_hvt ad=0.135 pd=1.27 as=0.135 ps=1.27 w=1 l=0.15
X2 VPWR B Y VPB sky130_fd_pr__pfet_01v8_hvt ad=0.135 pd=1.27 as=0.135 ps=1.27 w=1 l=0.15
X3 a_27_47# B VGND VNB sky130_fd_pr__nfet_01v8 ad=0.08775 pd=0.92 as=0.08775 ps=0.92 w=0.65 l=0.15
X4 a_27_47# A Y VNB sky130_fd_pr__nfet_01v8 ad=0.169 pd=1.82 as=0.08775 ps=0.92 w=0.65 l=0.15
X5 Y A a_27_47# VNB sky130_fd_pr__nfet_01v8 ad=0.08775 pd=0.92 as=0.08775 ps=0.92 w=0.65 l=0.15
X6 Y B VPWR VPB sky130_fd_pr__pfet_01v8_hvt ad=0.135 pd=1.27 as=0.26 ps=2.52 w=1 l=0.15
X7 VGND B a_27_47# VNB sky130_fd_pr__nfet_01v8 ad=0.08775 pd=0.92 as=0.169 ps=1.82 w=0.65 l=0.15
.ends

.subckt sky130_fd_sc_hd__a21oi_4 VNB VPB VGND VPWR A2 B1 Y A1
X0 a_28_297# B1 Y VPB sky130_fd_pr__pfet_01v8_hvt ad=0.14 pd=1.28 as=0.14 ps=1.28 w=1 l=0.15
X1 a_462_47# A1 Y VNB sky130_fd_pr__nfet_01v8 ad=0.091 pd=0.93 as=0.091 ps=0.93 w=0.65 l=0.15
X2 Y B1 a_28_297# VPB sky130_fd_pr__pfet_01v8_hvt ad=0.14 pd=1.28 as=0.26 ps=2.52 w=1 l=0.15
X3 Y B1 VGND VNB sky130_fd_pr__nfet_01v8 ad=0.091 pd=0.93 as=0.091 ps=0.93 w=0.65 l=0.15
X4 a_462_47# A1 Y VNB sky130_fd_pr__nfet_01v8 ad=0.091 pd=0.93 as=0.091 ps=0.93 w=0.65 l=0.15
X5 a_28_297# A2 VPWR VPB sky130_fd_pr__pfet_01v8_hvt ad=0.14 pd=1.28 as=0.14 ps=1.28 w=1 l=0.15
X6 a_462_47# A2 VGND VNB sky130_fd_pr__nfet_01v8 ad=0.091 pd=0.93 as=0.104 ps=0.97 w=0.65 l=0.15
X7 Y B1 a_28_297# VPB sky130_fd_pr__pfet_01v8_hvt ad=0.14 pd=1.28 as=0.14 ps=1.28 w=1 l=0.15
X8 VGND B1 Y VNB sky130_fd_pr__nfet_01v8 ad=0.104 pd=0.97 as=0.091 ps=0.93 w=0.65 l=0.15
X9 VGND B1 Y VNB sky130_fd_pr__nfet_01v8 ad=0.091 pd=0.93 as=0.091 ps=0.93 w=0.65 l=0.15
X10 Y A1 a_462_47# VNB sky130_fd_pr__nfet_01v8 ad=0.091 pd=0.93 as=0.091 ps=0.93 w=0.65 l=0.15
X11 a_28_297# A1 VPWR VPB sky130_fd_pr__pfet_01v8_hvt ad=0.14 pd=1.28 as=0.145 ps=1.29 w=1 l=0.15
X12 VPWR A2 a_28_297# VPB sky130_fd_pr__pfet_01v8_hvt ad=0.14 pd=1.28 as=0.14 ps=1.28 w=1 l=0.15
X13 Y B1 VGND VNB sky130_fd_pr__nfet_01v8 ad=0.091 pd=0.93 as=0.17225 ps=1.83 w=0.65 l=0.15
X14 VGND A2 a_462_47# VNB sky130_fd_pr__nfet_01v8 ad=0.17225 pd=1.83 as=0.091 ps=0.93 w=0.65 l=0.15
X15 a_28_297# B1 Y VPB sky130_fd_pr__pfet_01v8_hvt ad=0.155 pd=1.31 as=0.14 ps=1.28 w=1 l=0.15
X16 VPWR A1 a_28_297# VPB sky130_fd_pr__pfet_01v8_hvt ad=0.14 pd=1.28 as=0.14 ps=1.28 w=1 l=0.15
X17 a_28_297# A1 VPWR VPB sky130_fd_pr__pfet_01v8_hvt ad=0.14 pd=1.28 as=0.14 ps=1.28 w=1 l=0.15
X18 VGND A2 a_462_47# VNB sky130_fd_pr__nfet_01v8 ad=0.091 pd=0.93 as=0.091 ps=0.93 w=0.65 l=0.15
X19 VPWR A2 a_28_297# VPB sky130_fd_pr__pfet_01v8_hvt ad=0.145 pd=1.29 as=0.155 ps=1.31 w=1 l=0.15
X20 a_28_297# A2 VPWR VPB sky130_fd_pr__pfet_01v8_hvt ad=0.265 pd=2.53 as=0.14 ps=1.28 w=1 l=0.15
X21 Y A1 a_462_47# VNB sky130_fd_pr__nfet_01v8 ad=0.091 pd=0.93 as=0.091 ps=0.93 w=0.65 l=0.15
X22 a_462_47# A2 VGND VNB sky130_fd_pr__nfet_01v8 ad=0.091 pd=0.93 as=0.091 ps=0.93 w=0.65 l=0.15
X23 VPWR A1 a_28_297# VPB sky130_fd_pr__pfet_01v8_hvt ad=0.14 pd=1.28 as=0.14 ps=1.28 w=1 l=0.15
.ends

.subckt sky130_fd_sc_hd__o2111ai_1 VPB VNB VGND VPWR Y A1 A2 C1 D1 B1
X0 VPWR C1 Y VPB sky130_fd_pr__pfet_01v8_hvt ad=0.195 pd=1.39 as=0.14 ps=1.28 w=1 l=0.15
X1 a_235_47# C1 a_163_47# VNB sky130_fd_pr__nfet_01v8 ad=0.12675 pd=1.04 as=0.06825 ps=0.86 w=0.65 l=0.15
X2 a_343_47# B1 a_235_47# VNB sky130_fd_pr__nfet_01v8 ad=0.13162 pd=1.055 as=0.12675 ps=1.04 w=0.65 l=0.15
X3 Y B1 VPWR VPB sky130_fd_pr__pfet_01v8_hvt ad=0.2025 pd=1.405 as=0.195 ps=1.39 w=1 l=0.15
X4 a_454_297# A2 Y VPB sky130_fd_pr__pfet_01v8_hvt ad=0.195 pd=1.39 as=0.2025 ps=1.405 w=1 l=0.15
X5 Y D1 VPWR VPB sky130_fd_pr__pfet_01v8_hvt ad=0.14 pd=1.28 as=0.265 ps=2.53 w=1 l=0.15
X6 VPWR A1 a_454_297# VPB sky130_fd_pr__pfet_01v8_hvt ad=0.265 pd=2.53 as=0.195 ps=1.39 w=1 l=0.15
X7 a_163_47# D1 Y VNB sky130_fd_pr__nfet_01v8 ad=0.06825 pd=0.86 as=0.17225 ps=1.83 w=0.65 l=0.15
X8 VGND A2 a_343_47# VNB sky130_fd_pr__nfet_01v8 ad=0.12675 pd=1.04 as=0.13162 ps=1.055 w=0.65 l=0.15
X9 a_343_47# A1 VGND VNB sky130_fd_pr__nfet_01v8 ad=0.17225 pd=1.83 as=0.12675 ps=1.04 w=0.65 l=0.15
.ends

.subckt sky130_fd_sc_hd__o21ba_1 VNB VPB VGND VPWR B1_N A1 A2 X
X0 a_222_93# B1_N VGND VNB sky130_fd_pr__nfet_01v8 ad=0.1092 pd=1.36 as=0.10025 ps=0.985 w=0.42 l=0.15
X1 VPWR A1 a_544_297# VPB sky130_fd_pr__pfet_01v8_hvt ad=0.28 pd=2.56 as=0.105 ps=1.21 w=1 l=0.15
X2 VGND a_79_199# X VNB sky130_fd_pr__nfet_01v8 ad=0.10025 pd=0.985 as=0.169 ps=1.82 w=0.65 l=0.15
X3 a_222_93# B1_N VPWR VPB sky130_fd_pr__pfet_01v8_hvt ad=0.1176 pd=1.4 as=0.18575 ps=1.415 w=0.42 l=0.15
X4 VGND A2 a_448_47# VNB sky130_fd_pr__nfet_01v8 ad=0.08775 pd=0.92 as=0.10725 ps=0.98 w=0.65 l=0.15
X5 a_448_47# a_222_93# a_79_199# VNB sky130_fd_pr__nfet_01v8 ad=0.10725 pd=0.98 as=0.169 ps=1.82 w=0.65 l=0.15
X6 a_79_199# a_222_93# VPWR VPB sky130_fd_pr__pfet_01v8_hvt ad=0.165 pd=1.33 as=0.3 ps=2.6 w=1 l=0.15
X7 a_544_297# A2 a_79_199# VPB sky130_fd_pr__pfet_01v8_hvt ad=0.105 pd=1.21 as=0.165 ps=1.33 w=1 l=0.15
X8 a_448_47# A1 VGND VNB sky130_fd_pr__nfet_01v8 ad=0.17225 pd=1.83 as=0.08775 ps=0.92 w=0.65 l=0.15
X9 VPWR a_79_199# X VPB sky130_fd_pr__pfet_01v8_hvt ad=0.18575 pd=1.415 as=0.26 ps=2.52 w=1 l=0.15
.ends

.subckt sky130_fd_sc_hd__nor3b_1 VPB VNB VGND VPWR C_N B Y A
X0 VGND a_91_199# Y VNB sky130_fd_pr__nfet_01v8 ad=0.08775 pd=0.92 as=0.221 ps=1.98 w=0.65 l=0.15
X1 Y B VGND VNB sky130_fd_pr__nfet_01v8 ad=0.08775 pd=0.92 as=0.08775 ps=0.92 w=0.65 l=0.15
X2 VPWR A a_245_297# VPB sky130_fd_pr__pfet_01v8_hvt ad=0.14575 pd=1.335 as=0.135 ps=1.27 w=1 l=0.15
X3 a_91_199# C_N VGND VNB sky130_fd_pr__nfet_01v8 ad=0.1092 pd=1.36 as=0.10025 ps=0.985 w=0.42 l=0.15
X4 VGND A Y VNB sky130_fd_pr__nfet_01v8 ad=0.10025 pd=0.985 as=0.08775 ps=0.92 w=0.65 l=0.15
X5 a_245_297# B a_161_297# VPB sky130_fd_pr__pfet_01v8_hvt ad=0.135 pd=1.27 as=0.135 ps=1.27 w=1 l=0.15
X6 a_91_199# C_N VPWR VPB sky130_fd_pr__pfet_01v8_hvt ad=0.1092 pd=1.36 as=0.14575 ps=1.335 w=0.42 l=0.15
X7 a_161_297# a_91_199# Y VPB sky130_fd_pr__pfet_01v8_hvt ad=0.135 pd=1.27 as=0.32 ps=2.64 w=1 l=0.15
.ends

.subckt sky130_fd_sc_hd__o41ai_1 VNB VPB VGND VPWR A1 A2 A3 A4 Y B1
X0 a_348_297# A3 a_193_297# VPB sky130_fd_pr__pfet_01v8_hvt ad=0.135 pd=1.27 as=0.3125 ps=1.625 w=1 l=0.15
X1 a_109_47# A1 VGND VNB sky130_fd_pr__nfet_01v8 ad=0.182 pd=1.86 as=0.11375 ps=1 w=0.65 l=0.15
X2 a_193_297# A4 Y VPB sky130_fd_pr__pfet_01v8_hvt ad=0.3125 pd=1.625 as=0.135 ps=1.27 w=1 l=0.15
X3 VPWR A1 a_432_297# VPB sky130_fd_pr__pfet_01v8_hvt ad=0.28 pd=2.56 as=0.175 ps=1.35 w=1 l=0.15
X4 VGND A4 a_109_47# VNB sky130_fd_pr__nfet_01v8 ad=0.08775 pd=0.92 as=0.20312 ps=1.275 w=0.65 l=0.15
X5 VGND A2 a_109_47# VNB sky130_fd_pr__nfet_01v8 ad=0.11375 pd=1 as=0.08775 ps=0.92 w=0.65 l=0.15
X6 a_109_47# A3 VGND VNB sky130_fd_pr__nfet_01v8 ad=0.08775 pd=0.92 as=0.08775 ps=0.92 w=0.65 l=0.15
X7 a_432_297# A2 a_348_297# VPB sky130_fd_pr__pfet_01v8_hvt ad=0.175 pd=1.35 as=0.135 ps=1.27 w=1 l=0.15
X8 Y B1 VPWR VPB sky130_fd_pr__pfet_01v8_hvt ad=0.135 pd=1.27 as=0.26 ps=2.52 w=1 l=0.15
X9 a_109_47# B1 Y VNB sky130_fd_pr__nfet_01v8 ad=0.20312 pd=1.275 as=0.169 ps=1.82 w=0.65 l=0.15
.ends

.subckt sky130_fd_sc_hd__nor2_4 VPB VNB VGND VPWR Y B A
X0 VPWR A a_27_297# VPB sky130_fd_pr__pfet_01v8_hvt ad=0.135 pd=1.27 as=0.135 ps=1.27 w=1 l=0.15
X1 Y A VGND VNB sky130_fd_pr__nfet_01v8 ad=0.08775 pd=0.92 as=0.08775 ps=0.92 w=0.65 l=0.15
X2 a_27_297# A VPWR VPB sky130_fd_pr__pfet_01v8_hvt ad=0.135 pd=1.27 as=0.135 ps=1.27 w=1 l=0.15
X3 VGND A Y VNB sky130_fd_pr__nfet_01v8 ad=0.08775 pd=0.92 as=0.08775 ps=0.92 w=0.65 l=0.15
X4 a_27_297# B Y VPB sky130_fd_pr__pfet_01v8_hvt ad=0.27 pd=2.54 as=0.135 ps=1.27 w=1 l=0.15
X5 Y A VGND VNB sky130_fd_pr__nfet_01v8 ad=0.08775 pd=0.92 as=0.182 ps=1.86 w=0.65 l=0.15
X6 VGND A Y VNB sky130_fd_pr__nfet_01v8 ad=0.08775 pd=0.92 as=0.08775 ps=0.92 w=0.65 l=0.15
X7 VGND B Y VNB sky130_fd_pr__nfet_01v8 ad=0.08775 pd=0.92 as=0.08775 ps=0.92 w=0.65 l=0.15
X8 VGND B Y VNB sky130_fd_pr__nfet_01v8 ad=0.169 pd=1.82 as=0.08775 ps=0.92 w=0.65 l=0.15
X9 Y B a_27_297# VPB sky130_fd_pr__pfet_01v8_hvt ad=0.135 pd=1.27 as=0.135 ps=1.27 w=1 l=0.15
X10 VPWR A a_27_297# VPB sky130_fd_pr__pfet_01v8_hvt ad=0.135 pd=1.27 as=0.28 ps=2.56 w=1 l=0.15
X11 Y B VGND VNB sky130_fd_pr__nfet_01v8 ad=0.08775 pd=0.92 as=0.08775 ps=0.92 w=0.65 l=0.15
X12 Y B VGND VNB sky130_fd_pr__nfet_01v8 ad=0.08775 pd=0.92 as=0.08775 ps=0.92 w=0.65 l=0.15
X13 a_27_297# B Y VPB sky130_fd_pr__pfet_01v8_hvt ad=0.135 pd=1.27 as=0.135 ps=1.27 w=1 l=0.15
X14 Y B a_27_297# VPB sky130_fd_pr__pfet_01v8_hvt ad=0.135 pd=1.27 as=0.135 ps=1.27 w=1 l=0.15
X15 a_27_297# A VPWR VPB sky130_fd_pr__pfet_01v8_hvt ad=0.135 pd=1.27 as=0.135 ps=1.27 w=1 l=0.15
.ends

.subckt sky130_fd_sc_hd__a311oi_1 VPB VNB Y C1 B1 A1 A2 A3 VPWR VGND
X0 Y A1 a_194_47# VNB sky130_fd_pr__nfet_01v8 ad=0.11537 pd=1.005 as=0.091 ps=0.93 w=0.65 l=0.15
X1 a_194_47# A2 a_109_47# VNB sky130_fd_pr__nfet_01v8 ad=0.091 pd=0.93 as=0.08937 ps=0.925 w=0.65 l=0.15
X2 Y C1 a_376_297# VPB sky130_fd_pr__pfet_01v8_hvt ad=0.26 pd=2.52 as=0.1725 ps=1.345 w=1 l=0.15
X3 VPWR A2 a_109_297# VPB sky130_fd_pr__pfet_01v8_hvt ad=0.14 pd=1.28 as=0.1375 ps=1.275 w=1 l=0.15
X4 Y C1 VGND VNB sky130_fd_pr__nfet_01v8 ad=0.169 pd=1.82 as=0.11213 ps=0.995 w=0.65 l=0.15
X5 VGND B1 Y VNB sky130_fd_pr__nfet_01v8 ad=0.11213 pd=0.995 as=0.11537 ps=1.005 w=0.65 l=0.15
X6 a_109_297# A1 VPWR VPB sky130_fd_pr__pfet_01v8_hvt ad=0.165 pd=1.33 as=0.14 ps=1.28 w=1 l=0.15
X7 a_376_297# B1 a_109_297# VPB sky130_fd_pr__pfet_01v8_hvt ad=0.1725 pd=1.345 as=0.165 ps=1.33 w=1 l=0.15
X8 a_109_297# A3 VPWR VPB sky130_fd_pr__pfet_01v8_hvt ad=0.1375 pd=1.275 as=0.26 ps=2.52 w=1 l=0.15
X9 a_109_47# A3 VGND VNB sky130_fd_pr__nfet_01v8 ad=0.08937 pd=0.925 as=0.169 ps=1.82 w=0.65 l=0.15
.ends

.subckt simple_cpu_v4 VGND VPWR clk dbg_pc[0] dbg_pc[10] dbg_pc[11] dbg_pc[1] dbg_pc[2]
+ dbg_pc[3] dbg_pc[4] dbg_pc[5] dbg_pc[6] dbg_pc[7] dbg_pc[8] dbg_pc[9] mem_addr[0]
+ mem_addr[10] mem_addr[11] mem_addr[1] mem_addr[2] mem_addr[3] mem_addr[4] mem_addr[5]
+ mem_addr[6] mem_addr[7] mem_addr[8] mem_addr[9] mem_rdata[0] mem_rdata[10] mem_rdata[11]
+ mem_rdata[12] mem_rdata[13] mem_rdata[14] mem_rdata[15] mem_rdata[1] mem_rdata[2]
+ mem_rdata[3] mem_rdata[4] mem_rdata[5] mem_rdata[6] mem_rdata[7] mem_rdata[8] mem_rdata[9]
+ mem_wdata[0] mem_wdata[10] mem_wdata[11] mem_wdata[12] mem_wdata[13] mem_wdata[14]
+ mem_wdata[15] mem_wdata[1] mem_wdata[2] mem_wdata[3] mem_wdata[4] mem_wdata[5] mem_wdata[6]
+ mem_wdata[7] mem_wdata[8] mem_wdata[9] mem_we rst
XFILLER_54_236 VPWR VGND VPWR VGND sky130_fd_sc_hd__decap_6
XFILLER_27_417 VPWR VGND VPWR VGND sky130_fd_sc_hd__decap_3
X_2037_ VPWR VGND _2037_/X _2037_/A VPWR VGND sky130_fd_sc_hd__buf_2
Xhold362 _1893_/D _1830_/Q VPWR VGND VGND VPWR sky130_fd_sc_hd__dlygate4sd3_1
Xhold351 _1897_/D _2004_/Q VPWR VGND VGND VPWR sky130_fd_sc_hd__dlygate4sd3_1
Xhold395 _1333_/A _1996_/Q VPWR VGND VGND VPWR sky130_fd_sc_hd__dlygate4sd3_1
Xhold384 _2012_/D _1818_/Q VPWR VGND VGND VPWR sky130_fd_sc_hd__dlygate4sd3_1
Xhold373 _2003_/D _1809_/Q VPWR VGND VGND VPWR sky130_fd_sc_hd__dlygate4sd3_1
XFILLER_26_85 VGND VPWR VPWR VGND sky130_fd_sc_hd__decap_12
XFILLER_13_133 VPWR VGND VPWR VGND sky130_fd_sc_hd__decap_3
XFILLER_42_40 VGND VPWR VPWR VGND sky130_fd_sc_hd__decap_12
XFILLER_5_321 VGND VPWR VPWR VGND sky130_fd_sc_hd__decap_12
X_1270_ VPWR VGND VGND VPWR _1892_/Q _1273_/B _1270_/B sky130_fd_sc_hd__nand2_1
X_1606_ VPWR VGND VPWR VGND _2026_/A _1606_/C _1606_/D _1607_/B _2027_/A sky130_fd_sc_hd__nand4_1
X_0985_ VPWR VGND VGND VPWR _0992_/A _0981_/Y _1981_/D _0884_/A _0984_/Y _0982_/Y
+ sky130_fd_sc_hd__o221ai_1
X_1468_ VGND VPWR VGND VPWR _1467_/Y _2018_/A _1468_/Y _1553_/B sky130_fd_sc_hd__o21ai_0
X_1537_ VPWR VGND VGND VPWR hold405/X _1679_/A _1914_/D sky130_fd_sc_hd__nor2b_1
Xfanout105 VPWR VGND _1686_/A _1647_/A VPWR VGND sky130_fd_sc_hd__buf_2
X_1399_ VGND VPWR VPWR VGND _1747_/D _1402_/B _1847_/Q sky130_fd_sc_hd__and2_0
XFILLER_27_225 VGND VPWR VPWR VGND sky130_fd_sc_hd__decap_12
XFILLER_50_294 VPWR VGND VPWR VGND sky130_fd_sc_hd__decap_6
XFILLER_2_357 VPWR VGND VPWR VGND sky130_fd_sc_hd__decap_6
X_1253_ VGND VPWR VPWR VGND _1253_/X _2017_/A _1253_/S _1978_/Q sky130_fd_sc_hd__mux2_1
XFILLER_68_125 VPWR VGND VPWR VGND sky130_fd_sc_hd__decap_3
X_1322_ VPWR VGND VGND VPWR _1873_/Q _1323_/B _1320_/Y _1318_/Y _1314_/B sky130_fd_sc_hd__o211ai_1
XFILLER_56_309 VGND VPWR VPWR VGND sky130_fd_sc_hd__decap_12
X_1184_ VPWR VGND VGND VPWR _1165_/B _1183_/Y _1339_/A1 _1184_/X sky130_fd_sc_hd__o21a_1
XFILLER_24_239 VGND VPWR VPWR VGND sky130_fd_sc_hd__decap_4
X_0968_ VGND VPWR VPWR VGND _1925_/Q _0968_/Y _0966_/X _0974_/A _0934_/B _0967_/Y
+ sky130_fd_sc_hd__a32oi_1
X_0899_ VGND VPWR VPWR VGND _1879_/Q _0970_/B _0900_/B sky130_fd_sc_hd__xor2_1
XFILLER_55_342 VPWR VGND VPWR VGND sky130_fd_sc_hd__decap_8
XFILLER_70_323 VGND VPWR VPWR VGND sky130_fd_sc_hd__decap_12
XFILLER_70_301 VPWR VGND VPWR VGND sky130_fd_sc_hd__decap_6
XFILLER_30_209 VPWR VGND VPWR VGND sky130_fd_sc_hd__decap_3
XFILLER_7_405 VGND VPWR VPWR VGND sky130_fd_sc_hd__decap_12
XFILLER_2_121 VGND VPWR VPWR VGND sky130_fd_sc_hd__decap_12
XFILLER_64_60 VPWR VGND VPWR VGND sky130_fd_sc_hd__decap_6
XFILLER_61_345 VPWR VGND VPWR VGND sky130_fd_sc_hd__decap_3
XFILLER_0_57 VGND VPWR VPWR VGND sky130_fd_sc_hd__decap_12
XFILLER_17_9 VGND VPWR VPWR VGND sky130_fd_sc_hd__decap_12
XFILLER_61_389 VPWR VGND VPWR VGND sky130_fd_sc_hd__decap_3
X_1940_ _1940_/Q _1967_/CLK _1940_/D VPWR VGND VPWR VGND sky130_fd_sc_hd__dfxtp_1
X_1871_ VPWR VGND _1977_/CLK _1652_/Y _1871_/Q _1871_/D VPWR VGND sky130_fd_sc_hd__edfxtp_1
XFILLER_50_3 VPWR VGND VPWR VGND sky130_fd_sc_hd__decap_3
X_1305_ VGND VPWR VGND VPWR _1305_/B _1305_/D _1305_/Y _1305_/A _1305_/C sky130_fd_sc_hd__nor4_2
X_1236_ VGND VPWR VPWR VGND _1846_/D _1495_/A1 _1238_/S _1981_/Q sky130_fd_sc_hd__mux2_1
XFILLER_71_109 VPWR VGND VPWR VGND sky130_fd_sc_hd__decap_3
X_1167_ VGND VPWR _1165_/Y _1138_/Y _1343_/B _1166_/A VPWR VGND sky130_fd_sc_hd__o21ai_1
XFILLER_52_356 VPWR VGND VPWR VGND sky130_fd_sc_hd__decap_8
X_1098_ VGND VPWR VPWR VGND _1885_/D _1096_/X _1826_/Q _1097_/X sky130_fd_sc_hd__mux2_1
XFILLER_12_209 VGND VPWR VPWR VGND sky130_fd_sc_hd__decap_12
XFILLER_60_29 VGND VPWR VPWR VGND sky130_fd_sc_hd__decap_12
XFILLER_20_253 VPWR VGND VPWR VGND sky130_fd_sc_hd__decap_8
XFILLER_69_27 VGND VPWR VPWR VGND sky130_fd_sc_hd__decap_12
XFILLER_43_378 VGND VPWR VPWR VGND sky130_fd_sc_hd__decap_4
XFILLER_43_356 VPWR VGND VPWR VGND sky130_fd_sc_hd__decap_6
XFILLER_43_345 VPWR VGND VPWR VGND sky130_fd_sc_hd__decap_6
XFILLER_34_85 VGND VPWR VPWR VGND sky130_fd_sc_hd__decap_12
XFILLER_61_164 VGND VPWR VPWR VGND sky130_fd_sc_hd__decap_4
X_1021_ VGND VPWR VGND VPWR _1288_/B1 _1288_/A1 _1933_/D _1015_/Y sky130_fd_sc_hd__o21ai_0
X_1923_ VPWR VGND _1987_/CLK _1925_/DE _1923_/Q _1923_/D VPWR VGND sky130_fd_sc_hd__edfxtp_1
X_1854_ VPWR VGND _1963_/CLK _1660_/Y _1854_/Q _1854_/D VPWR VGND sky130_fd_sc_hd__edfxtp_1
X_1785_ VPWR VGND _1788_/CLK _1790_/DE _1785_/Q _1785_/D VPWR VGND sky130_fd_sc_hd__edfxtp_1
XFILLER_69_231 VPWR VGND VPWR VGND sky130_fd_sc_hd__decap_6
XFILLER_69_275 VGND VPWR VPWR VGND sky130_fd_sc_hd__decap_4
X_1219_ VPWR VGND VGND VPWR _1219_/A _1222_/C _1219_/Y sky130_fd_sc_hd__nor2_1
XFILLER_37_150 VPWR VGND VPWR VGND sky130_fd_sc_hd__decap_6
XFILLER_52_197 VGND VPWR VPWR VGND sky130_fd_sc_hd__decap_12
XFILLER_4_249 VPWR VGND VPWR VGND sky130_fd_sc_hd__decap_3
XFILLER_20_65 VPWR VGND VPWR VGND sky130_fd_sc_hd__decap_6
XFILLER_20_76 VPWR VGND VPWR VGND sky130_fd_sc_hd__decap_8
Xinput301 VPWR VGND _1483_/A1 mem_rdata[9] VPWR VGND sky130_fd_sc_hd__buf_4
X_1570_ VPWR VGND VPWR VGND _2022_/A _1460_/B _1570_/Y hold415/X _1459_/B sky130_fd_sc_hd__a22oi_1
XFILLER_3_293 VGND VPWR VPWR VGND sky130_fd_sc_hd__decap_12
XFILLER_66_256 VPWR VGND VPWR VGND sky130_fd_sc_hd__decap_3
XFILLER_13_3 VGND VPWR VPWR VGND sky130_fd_sc_hd__decap_12
X_1004_ VPWR VGND VGND VPWR _1219_/A _1005_/B _1133_/A sky130_fd_sc_hd__nand2_1
XFILLER_34_197 VGND VPWR VPWR VGND sky130_fd_sc_hd__decap_4
XFILLER_22_304 VGND VPWR VPWR VGND sky130_fd_sc_hd__decap_4
X_1837_ VPWR VGND _1987_/CLK _1869_/DE _1837_/Q _1837_/D VPWR VGND sky130_fd_sc_hd__edfxtp_1
X_1906_ VPWR VGND clkload6/A _1634_/Y _2041_/A _1906_/D VPWR VGND sky130_fd_sc_hd__edfxtp_1
X_1768_ VPWR VGND clkload5/A _1774_/DE _1768_/Q _1768_/D VPWR VGND sky130_fd_sc_hd__edfxtp_1
XFILLER_57_245 VPWR VGND VPWR VGND sky130_fd_sc_hd__decap_6
X_1699_ VPWR VGND _1777_/CLK _1708_/DE _1699_/Q _1699_/D VPWR VGND sky130_fd_sc_hd__edfxtp_1
XFILLER_57_289 VGND VPWR VPWR VGND sky130_fd_sc_hd__decap_4
XFILLER_25_153 VPWR VGND VPWR VGND sky130_fd_sc_hd__decap_3
XFILLER_13_337 VGND VPWR VPWR VGND sky130_fd_sc_hd__decap_4
XFILLER_56_50 VGND VPWR VPWR VGND sky130_fd_sc_hd__decap_4
XFILLER_48_289 VGND VPWR VPWR VGND sky130_fd_sc_hd__decap_12
XFILLER_71_281 VPWR VGND VPWR VGND sky130_fd_sc_hd__decap_3
Xplace259 VPWR VGND _0974_/A _1994_/Q VPWR VGND sky130_fd_sc_hd__buf_2
Xplace237 VPWR VGND _1221_/B _1305_/B VPWR VGND sky130_fd_sc_hd__buf_2
Xplace204 VPWR VGND _1925_/DE _1926_/DE VPWR VGND sky130_fd_sc_hd__buf_2
Xplace248 VPWR VGND _1613_/B _1268_/Y VPWR VGND sky130_fd_sc_hd__buf_2
Xplace215 VPWR VGND _1817_/DE _1822_/DE VPWR VGND sky130_fd_sc_hd__buf_2
Xplace226 VPWR VGND _1418_/B _1527_/B VPWR VGND sky130_fd_sc_hd__buf_2
X_1622_ VGND VPWR VPWR VGND _1789_/D _1629_/B _1857_/Q sky130_fd_sc_hd__and2_0
X_1553_ VPWR VGND VGND VPWR _2026_/A _1553_/B _1553_/Y sky130_fd_sc_hd__nor2_1
X_1484_ VPWR VGND VGND VPWR _1689_/A _1691_/B _1957_/D sky130_fd_sc_hd__nor2_1
X_2036_ VPWR VGND _2036_/X _2036_/A VPWR VGND sky130_fd_sc_hd__buf_2
XFILLER_50_421 VGND VPWR VPWR VGND sky130_fd_sc_hd__decap_4
Xhold396 _1890_/D _1871_/Q VPWR VGND VGND VPWR sky130_fd_sc_hd__dlygate4sd3_1
Xhold363 _1351_/A _2000_/Q VPWR VGND VGND VPWR sky130_fd_sc_hd__dlygate4sd3_1
Xhold385 _2011_/D _1817_/Q VPWR VGND VGND VPWR sky130_fd_sc_hd__dlygate4sd3_1
Xhold352 _1904_/D _2011_/Q VPWR VGND VGND VPWR sky130_fd_sc_hd__dlygate4sd3_1
Xhold374 _2013_/D _1819_/Q VPWR VGND VGND VPWR sky130_fd_sc_hd__dlygate4sd3_1
XFILLER_18_407 VPWR VGND VPWR VGND sky130_fd_sc_hd__decap_8
Xclkbuf_3_6__f_clk VGND VPWR VGND VPWR clkbuf_0_clk/X clkbuf_3_6__f_clk/X sky130_fd_sc_hd__clkbuf_16
XFILLER_26_97 VGND VPWR VPWR VGND sky130_fd_sc_hd__decap_4
XFILLER_42_52 VPWR VGND VPWR VGND sky130_fd_sc_hd__decap_3
XPHY_EDGE_ROW_39_Left_111 VPWR VGND VPWR VGND sky130_fd_sc_hd__decap_3
XFILLER_5_333 VPWR VGND VPWR VGND sky130_fd_sc_hd__decap_3
XFILLER_13_189 VGND VPWR VPWR VGND sky130_fd_sc_hd__decap_4
XFILLER_3_57 VGND VPWR VPWR VGND sky130_fd_sc_hd__decap_12
XPHY_EDGE_ROW_48_Left_120 VPWR VGND VPWR VGND sky130_fd_sc_hd__decap_3
X_0984_ VGND VPWR VGND VPWR _0983_/Y _1834_/Q _0984_/Y _0931_/C sky130_fd_sc_hd__o21ai_0
XFILLER_32_421 VGND VPWR VPWR VGND sky130_fd_sc_hd__decap_4
X_1536_ VPWR VGND VGND VPWR _1911_/D _1536_/B _1915_/D sky130_fd_sc_hd__nor2_1
X_1605_ VGND VPWR VPWR VGND _1801_/D _1621_/B _1853_/Q sky130_fd_sc_hd__and2_0
X_1467_ VPWR VGND VPWR VGND _1459_/B _0848_/Y _1688_/A _1467_/Y sky130_fd_sc_hd__a21oi_1
X_1398_ VGND VPWR VPWR VGND _1748_/D _1402_/B _1848_/Q sky130_fd_sc_hd__and2_0
X_2019_ VPWR VGND _2019_/X _2019_/A VPWR VGND sky130_fd_sc_hd__buf_2
XFILLER_50_240 VGND VPWR VPWR VGND sky130_fd_sc_hd__decap_4
XFILLER_35_270 VPWR VGND VPWR VGND sky130_fd_sc_hd__decap_8
XFILLER_27_237 VPWR VGND VPWR VGND sky130_fd_sc_hd__decap_8
XFILLER_37_41 VPWR VGND VPWR VGND sky130_fd_sc_hd__decap_8
XFILLER_41_273 VPWR VGND VPWR VGND sky130_fd_sc_hd__decap_6
XFILLER_14_421 VGND VPWR VPWR VGND sky130_fd_sc_hd__decap_4
XFILLER_5_141 VGND VPWR VPWR VGND sky130_fd_sc_hd__decap_12
X_1252_ VGND VPWR VPWR VGND _1252_/X _2018_/A _1253_/S _1979_/Q sky130_fd_sc_hd__mux2_1
X_1321_ VGND VPWR _1321_/B _1323_/A _1871_/Q VPWR VGND sky130_fd_sc_hd__xnor2_1
XFILLER_64_365 VPWR VGND VPWR VGND sky130_fd_sc_hd__decap_8
X_1183_ VPWR VGND VGND VPWR _1183_/A _1183_/B _1183_/Y sky130_fd_sc_hd__nor2_1
XFILLER_17_281 VGND VPWR VPWR VGND sky130_fd_sc_hd__decap_12
X_0967_ VPWR VGND VGND VPWR _1837_/Q _0974_/B _0967_/Y sky130_fd_sc_hd__nand2b_1
XFILLER_58_29 VGND VPWR VPWR VGND sky130_fd_sc_hd__decap_4
X_1519_ VPWR VGND VGND VPWR _1833_/D _1520_/B _2019_/A _1521_/S sky130_fd_sc_hd__mux2i_1
X_0898_ VPWR VGND VGND VPWR _0970_/A _0976_/A _1878_/Q _0898_/B sky130_fd_sc_hd__maj3_1
XPHY_EDGE_ROW_12_Right_12 VPWR VGND VPWR VGND sky130_fd_sc_hd__decap_3
XFILLER_55_354 VGND VPWR VPWR VGND sky130_fd_sc_hd__decap_4
XPHY_EDGE_ROW_21_Right_21 VPWR VGND VPWR VGND sky130_fd_sc_hd__decap_3
XPHY_EDGE_ROW_30_Right_30 VPWR VGND VPWR VGND sky130_fd_sc_hd__decap_3
XFILLER_7_417 VPWR VGND VPWR VGND sky130_fd_sc_hd__decap_8
XFILLER_2_133 VPWR VGND VPWR VGND sky130_fd_sc_hd__decap_6
XFILLER_46_365 VGND VPWR VPWR VGND sky130_fd_sc_hd__decap_12
XFILLER_46_321 VPWR VGND VPWR VGND sky130_fd_sc_hd__decap_8
XFILLER_0_69 VGND VPWR VPWR VGND sky130_fd_sc_hd__decap_12
X_1870_ VPWR VGND _1994_/CLK _1917_/DE _1870_/Q _1870_/D VPWR VGND sky130_fd_sc_hd__edfxtp_1
XPHY_EDGE_ROW_24_Left_96 VPWR VGND VPWR VGND sky130_fd_sc_hd__decap_3
X_1166_ VPWR VGND VGND VPWR _1138_/Y _1166_/A _1166_/Y sky130_fd_sc_hd__nor2b_1
X_1304_ VPWR VGND VGND VPWR _1963_/Q _1353_/B _1304_/C _1305_/D sky130_fd_sc_hd__nor3_2
X_1235_ VGND VPWR VPWR VGND _1847_/D _1493_/A1 _1238_/S _1982_/Q sky130_fd_sc_hd__mux2_1
X_1097_ VGND VPWR VGND VPWR _1827_/Q _1754_/Q _1722_/Q _1828_/Q _1786_/Q _1818_/Q
+ _1097_/X sky130_fd_sc_hd__mux4_2
XFILLER_69_39 VGND VPWR VPWR VGND sky130_fd_sc_hd__decap_12
X_1999_ _1999_/Q _2000_/CLK _1999_/D VPWR VGND VPWR VGND sky130_fd_sc_hd__dfxtp_1
XFILLER_70_121 VGND VPWR VPWR VGND sky130_fd_sc_hd__decap_4
XFILLER_28_398 VGND VPWR VPWR VGND sky130_fd_sc_hd__decap_12
XFILLER_28_365 VPWR VGND VPWR VGND sky130_fd_sc_hd__decap_6
XFILLER_28_321 VPWR VGND VPWR VGND sky130_fd_sc_hd__decap_8
XFILLER_50_85 VPWR VGND VPWR VGND sky130_fd_sc_hd__decap_6
XFILLER_66_405 VGND VPWR VPWR VGND sky130_fd_sc_hd__decap_12
X_1020_ VGND VPWR VPWR VGND _1140_/B _1020_/Y _1305_/A _1307_/A _1353_/C _1358_/C
+ sky130_fd_sc_hd__a32oi_1
X_1922_ VPWR VGND _1954_/CLK _1922_/DE _1922_/Q _1922_/D VPWR VGND sky130_fd_sc_hd__edfxtp_1
XFILLER_19_398 VGND VPWR VPWR VGND sky130_fd_sc_hd__decap_12
X_1853_ VPWR VGND clkload9/A _1661_/Y _1853_/Q _1853_/D VPWR VGND sky130_fd_sc_hd__edfxtp_1
X_1784_ VPWR VGND clkload5/A _1790_/DE _1784_/Q _1784_/D VPWR VGND sky130_fd_sc_hd__edfxtp_1
X_1149_ VGND VPWR _1952_/Q _1203_/A _1940_/Q VPWR VGND sky130_fd_sc_hd__xnor2_1
X_1218_ VPWR VGND VGND VPWR _1218_/A _1218_/B _1218_/Y sky130_fd_sc_hd__nor2_1
XFILLER_52_110 VPWR VGND VPWR VGND sky130_fd_sc_hd__decap_3
XFILLER_71_29 VGND VPWR VPWR VGND sky130_fd_sc_hd__decap_12
Xinput302 VPWR VGND _1647_/A rst VPWR VGND sky130_fd_sc_hd__buf_4
XFILLER_39_405 VGND VPWR VPWR VGND sky130_fd_sc_hd__decap_12
XFILLER_3_261 VGND VPWR VPWR VGND sky130_fd_sc_hd__decap_12
X_1003_ VPWR VGND VGND VPWR _1209_/B _1133_/A _1157_/B sky130_fd_sc_hd__nor2_2
X_1905_ VPWR VGND _1963_/CLK _1635_/Y _2040_/A _1905_/D VPWR VGND sky130_fd_sc_hd__edfxtp_1
XFILLER_34_165 VPWR VGND VPWR VGND sky130_fd_sc_hd__decap_8
XFILLER_30_360 VGND VPWR VPWR VGND sky130_fd_sc_hd__decap_4
XFILLER_22_349 VPWR VGND VPWR VGND sky130_fd_sc_hd__decap_3
X_1836_ VPWR VGND _1984_/CLK _1878_/DE _1836_/Q _1836_/D VPWR VGND sky130_fd_sc_hd__edfxtp_1
X_1767_ VPWR VGND clkload1/A _1770_/DE _1767_/Q _1767_/D VPWR VGND sky130_fd_sc_hd__edfxtp_1
XPHY_EDGE_ROW_6_Right_6 VPWR VGND VPWR VGND sky130_fd_sc_hd__decap_3
X_1698_ VPWR VGND _1777_/CLK _1708_/DE _1698_/Q _1698_/D VPWR VGND sky130_fd_sc_hd__edfxtp_1
XFILLER_66_29 VGND VPWR VPWR VGND sky130_fd_sc_hd__decap_12
XPHY_EDGE_ROW_11_Left_83 VPWR VGND VPWR VGND sky130_fd_sc_hd__decap_3
XFILLER_13_316 VGND VPWR VPWR VGND sky130_fd_sc_hd__decap_12
XFILLER_0_231 VPWR VGND VPWR VGND sky130_fd_sc_hd__decap_3
XFILLER_0_253 VGND VPWR VPWR VGND sky130_fd_sc_hd__decap_12
XFILLER_63_216 VPWR VGND VPWR VGND sky130_fd_sc_hd__decap_8
Xplace205 VPWR VGND _1878_/DE _1926_/DE VPWR VGND sky130_fd_sc_hd__buf_2
Xplace216 VPWR VGND _1822_/DE _1266_/X VPWR VGND sky130_fd_sc_hd__buf_2
Xplace227 VPWR VGND _1758_/DE _1754_/DE VPWR VGND sky130_fd_sc_hd__buf_2
XPHY_EDGE_ROW_59_Right_59 VPWR VGND VPWR VGND sky130_fd_sc_hd__decap_3
Xplace249 VPWR VGND _0866_/B _0856_/Y VPWR VGND sky130_fd_sc_hd__buf_2
Xplace238 VPWR VGND _1288_/B1 _1020_/Y VPWR VGND sky130_fd_sc_hd__buf_2
XFILLER_31_146 VGND VPWR VPWR VGND sky130_fd_sc_hd__decap_12
XFILLER_31_113 VPWR VGND VPWR VGND sky130_fd_sc_hd__decap_3
X_1552_ VGND VPWR VGND VPWR _1546_/B _2026_/A _1552_/Y _1606_/D sky130_fd_sc_hd__o21ai_0
X_1621_ VGND VPWR VPWR VGND _1791_/D _1621_/B _1843_/Q sky130_fd_sc_hd__and2_0
XPHY_EDGE_ROW_68_Right_68 VPWR VGND VPWR VGND sky130_fd_sc_hd__decap_3
X_1483_ VPWR VGND VGND VPWR _1957_/Q _1691_/B _1483_/A1 _1584_/S sky130_fd_sc_hd__mux2i_1
X_2035_ VPWR VGND _2035_/X _2035_/A VPWR VGND sky130_fd_sc_hd__buf_2
XFILLER_30_190 VPWR VGND VPWR VGND sky130_fd_sc_hd__decap_6
Xhold375 _1842_/D _1947_/Q VPWR VGND VGND VPWR sky130_fd_sc_hd__dlygate4sd3_1
Xhold397 _1834_/D _1939_/Q VPWR VGND VGND VPWR sky130_fd_sc_hd__dlygate4sd3_1
Xhold364 _1340_/A _1999_/Q VPWR VGND VGND VPWR sky130_fd_sc_hd__dlygate4sd3_1
Xhold353 _1906_/D _2013_/Q VPWR VGND VGND VPWR sky130_fd_sc_hd__dlygate4sd3_1
X_1819_ VPWR VGND clkload2/A _1822_/DE _1819_/Q _1819_/D VPWR VGND sky130_fd_sc_hd__edfxtp_1
Xhold386 _2008_/D _1814_/Q VPWR VGND VGND VPWR sky130_fd_sc_hd__dlygate4sd3_1
XFILLER_13_113 VGND VPWR VPWR VGND sky130_fd_sc_hd__decap_12
XFILLER_3_69 VGND VPWR VPWR VGND sky130_fd_sc_hd__decap_12
XFILLER_44_282 VGND VPWR VPWR VGND sky130_fd_sc_hd__decap_12
X_0983_ VPWR VGND VPWR VGND _0931_/C _1834_/Q _0838_/Y _0983_/Y sky130_fd_sc_hd__a21oi_1
X_1535_ VPWR VGND VGND VPWR _1957_/Q _1538_/B _1536_/B sky130_fd_sc_hd__nor2_1
X_1604_ VGND VPWR VPWR VGND _1802_/D _1613_/B _1854_/Q sky130_fd_sc_hd__and2_0
X_1466_ VGND VPWR _2018_/A _1466_/Y _2017_/A VPWR VGND sky130_fd_sc_hd__xnor2_1
X_1397_ VGND VPWR VPWR VGND _1749_/D _1402_/B _1849_/Q sky130_fd_sc_hd__and2_0
X_2018_ VPWR VGND _2018_/X _2018_/A VPWR VGND sky130_fd_sc_hd__buf_2
XFILLER_37_64 VPWR VGND VPWR VGND sky130_fd_sc_hd__decap_8
XFILLER_41_285 VPWR VGND VPWR VGND sky130_fd_sc_hd__decap_8
X_1320_ VPWR VGND VPWR VGND _1314_/B _1873_/Q _1319_/Y _1320_/Y sky130_fd_sc_hd__a21oi_1
XFILLER_5_153 VGND VPWR VPWR VGND sky130_fd_sc_hd__decap_12
X_1182_ VPWR VGND VGND VPWR _1882_/D _1182_/Y _1305_/B sky130_fd_sc_hd__nand2_1
X_1251_ VGND VPWR VPWR VGND _1251_/X _2019_/A _1253_/S _1980_/Q sky130_fd_sc_hd__mux2_1
XFILLER_49_341 VPWR VGND VPWR VGND sky130_fd_sc_hd__decap_3
X_0966_ VPWR VGND VPWR VGND _1880_/Q _0997_/A _0998_/A1 _0966_/X sky130_fd_sc_hd__a21o_1
X_0897_ VGND VPWR VPWR VGND _1878_/Q _0976_/B _0898_/B sky130_fd_sc_hd__xor2_1
X_1449_ VGND VPWR VGND VPWR _1829_/Q _1935_/Q _1829_/D _1964_/Q _1449_/Y _1327_/Y
+ sky130_fd_sc_hd__a221oi_2
X_1518_ VPWR VGND VGND VPWR _1522_/A _1518_/B _1939_/D sky130_fd_sc_hd__nor2_1
XFILLER_70_347 VGND VPWR VPWR VGND sky130_fd_sc_hd__decap_12
XPHY_EDGE_ROW_67_Left_139 VPWR VGND VPWR VGND sky130_fd_sc_hd__decap_3
XFILLER_3_3 VGND VPWR VPWR VGND sky130_fd_sc_hd__decap_12
XFILLER_2_189 VPWR VGND VPWR VGND sky130_fd_sc_hd__decap_6
XFILLER_0_15 VGND VPWR VPWR VGND sky130_fd_sc_hd__decap_12
XFILLER_14_263 VPWR VGND VPWR VGND sky130_fd_sc_hd__decap_6
X_1303_ VGND VPWR VPWR VGND _1297_/Y _1296_/Y _1295_/Y _1303_/Y _1302_/Y sky130_fd_sc_hd__a31oi_1
X_1234_ VGND VPWR VPWR VGND _1848_/D _1491_/A1 _1349_/S _1983_/Q sky130_fd_sc_hd__mux2_1
XFILLER_64_141 VPWR VGND VPWR VGND sky130_fd_sc_hd__decap_6
X_1165_ VPWR VGND VGND VPWR _1165_/A _1165_/B _1165_/Y sky130_fd_sc_hd__nor2_1
X_1096_ VGND VPWR VGND VPWR _1827_/Q _1738_/Q _1706_/Q _1828_/Q _1770_/Q _1802_/Q
+ _1096_/X sky130_fd_sc_hd__mux4_2
X_1998_ _1998_/Q clkload8/A _1998_/D VPWR VGND VPWR VGND sky130_fd_sc_hd__dfxtp_1
X_0949_ VGND VPWR _0949_/B _0949_/Y _0949_/A VPWR VGND sky130_fd_sc_hd__xnor2_1
XFILLER_59_73 VGND VPWR VPWR VGND sky130_fd_sc_hd__decap_12
XFILLER_66_417 VPWR VGND VPWR VGND sky130_fd_sc_hd__decap_3
XFILLER_46_141 VGND VPWR VPWR VGND sky130_fd_sc_hd__decap_12
XFILLER_61_122 VGND VPWR VPWR VGND sky130_fd_sc_hd__decap_12
X_1921_ VPWR VGND _1954_/CLK _1922_/DE _1921_/Q _1921_/D VPWR VGND sky130_fd_sc_hd__edfxtp_1
X_1852_ VPWR VGND clkload9/A _1662_/Y _1852_/Q _1852_/D VPWR VGND sky130_fd_sc_hd__edfxtp_1
X_1783_ VPWR VGND clkload1/A _1786_/DE _1783_/Q _1783_/D VPWR VGND sky130_fd_sc_hd__edfxtp_1
X_1148_ VPWR VGND VGND VPWR _1941_/Q _1953_/Q _1148_/Y sky130_fd_sc_hd__nor2_1
X_1217_ VGND VPWR _1217_/B _1218_/B _1217_/A VPWR VGND sky130_fd_sc_hd__xnor2_1
X_1079_ VGND VPWR VGND VPWR _1083_/S0 _1776_/Q _1760_/Q _1083_/S1 _1792_/Q _1808_/Q
+ _1079_/X sky130_fd_sc_hd__mux4_2
XFILLER_63_409 VPWR VGND VPWR VGND sky130_fd_sc_hd__decap_8
XFILLER_28_141 VPWR VGND VPWR VGND sky130_fd_sc_hd__decap_3
XFILLER_45_53 VPWR VGND VPWR VGND sky130_fd_sc_hd__decap_3
XFILLER_31_306 VPWR VGND VPWR VGND sky130_fd_sc_hd__decap_6
XFILLER_3_273 VPWR VGND VPWR VGND sky130_fd_sc_hd__decap_6
X_1002_ VPWR VGND VPWR VGND _1963_/Q _1961_/Q _1353_/B _1007_/C _1960_/Q sky130_fd_sc_hd__nand4_1
X_1835_ VPWR VGND _1982_/CLK _1926_/DE _1835_/Q _1835_/D VPWR VGND sky130_fd_sc_hd__edfxtp_1
X_1904_ VPWR VGND clkload5/A _1636_/Y _2039_/A _1904_/D VPWR VGND sky130_fd_sc_hd__edfxtp_1
X_1697_ VPWR VGND _1777_/CLK _1708_/DE _1697_/Q _1697_/D VPWR VGND sky130_fd_sc_hd__edfxtp_1
X_1766_ VPWR VGND _2001_/CLK _1774_/DE _1766_/Q _1766_/D VPWR VGND sky130_fd_sc_hd__edfxtp_1
XFILLER_57_225 VGND VPWR VPWR VGND sky130_fd_sc_hd__decap_12
XFILLER_57_214 VGND VPWR VPWR VGND sky130_fd_sc_hd__decap_4
XFILLER_65_291 VGND VPWR VPWR VGND sky130_fd_sc_hd__decap_12
XFILLER_0_221 VPWR VGND VPWR VGND sky130_fd_sc_hd__decap_3
XFILLER_0_265 VGND VPWR VPWR VGND sky130_fd_sc_hd__decap_12
Xplace206 VPWR VGND _1926_/DE _1358_/D VPWR VGND sky130_fd_sc_hd__buf_2
XFILLER_56_85 VPWR VGND VPWR VGND sky130_fd_sc_hd__decap_8
Xplace228 VPWR VGND _1754_/DE _1272_/Y VPWR VGND sky130_fd_sc_hd__buf_2
XFILLER_16_111 VGND VPWR VPWR VGND sky130_fd_sc_hd__decap_12
Xplace217 VPWR VGND _1724_/DE _1726_/DE VPWR VGND sky130_fd_sc_hd__buf_2
Xplace239 VPWR VGND _1774_/DE _1770_/DE VPWR VGND sky130_fd_sc_hd__buf_2
XFILLER_31_169 VPWR VGND VPWR VGND sky130_fd_sc_hd__decap_8
XFILLER_31_158 VPWR VGND VPWR VGND sky130_fd_sc_hd__decap_3
XFILLER_31_125 VPWR VGND VPWR VGND sky130_fd_sc_hd__decap_3
XFILLER_8_321 VGND VPWR VPWR VGND sky130_fd_sc_hd__decap_12
X_1551_ VPWR VGND VGND VPWR _1551_/A _1551_/Y _1608_/A sky130_fd_sc_hd__nand2_1
X_1482_ VPWR VGND VGND VPWR _1689_/A _1689_/B _1958_/D sky130_fd_sc_hd__nor2_1
XFILLER_8_365 VGND VPWR VPWR VGND sky130_fd_sc_hd__decap_12
X_1620_ VGND VPWR VPWR VGND _1792_/D _1621_/B _1844_/Q sky130_fd_sc_hd__and2_0
XFILLER_39_225 VGND VPWR VPWR VGND sky130_fd_sc_hd__decap_12
XFILLER_62_294 VGND VPWR VPWR VGND sky130_fd_sc_hd__decap_12
X_2034_ VPWR VGND _2034_/X _2034_/A VPWR VGND sky130_fd_sc_hd__buf_2
X_1818_ VPWR VGND _2015_/CLK _1266_/X _1818_/Q _1818_/D VPWR VGND sky130_fd_sc_hd__edfxtp_1
XFILLER_10_309 VGND VPWR VPWR VGND sky130_fd_sc_hd__decap_4
Xhold365 _1338_/A _1998_/Q VPWR VGND VGND VPWR sky130_fd_sc_hd__dlygate4sd3_1
Xhold387 _1835_/D _1940_/Q VPWR VGND VGND VPWR sky130_fd_sc_hd__dlygate4sd3_1
Xhold398 _1891_/D _1872_/Q VPWR VGND VGND VPWR sky130_fd_sc_hd__dlygate4sd3_1
Xhold354 _1903_/D _2010_/Q VPWR VGND VGND VPWR sky130_fd_sc_hd__dlygate4sd3_1
Xhold376 _2002_/D _1808_/Q VPWR VGND VGND VPWR sky130_fd_sc_hd__dlygate4sd3_1
X_1749_ VPWR VGND _1749_/CLK _1754_/DE _1749_/Q _1749_/D VPWR VGND sky130_fd_sc_hd__edfxtp_1
XFILLER_45_217 VPWR VGND VPWR VGND sky130_fd_sc_hd__decap_6
XFILLER_26_44 VPWR VGND VPWR VGND sky130_fd_sc_hd__decap_6
XFILLER_13_125 VPWR VGND VPWR VGND sky130_fd_sc_hd__decap_8
XFILLER_68_309 VPWR VGND VPWR VGND sky130_fd_sc_hd__decap_6
XFILLER_67_51 VGND VPWR VPWR VGND sky130_fd_sc_hd__decap_4
XFILLER_3_15 VGND VPWR VPWR VGND sky130_fd_sc_hd__decap_12
XFILLER_44_294 VGND VPWR VPWR VGND sky130_fd_sc_hd__decap_12
X_0982_ VPWR VGND VPWR VGND _1877_/Q _0997_/A _0998_/A1 _0982_/Y sky130_fd_sc_hd__a21oi_1
X_1465_ VPWR VGND VPWR VGND _1464_/Y _1460_/Y _1522_/A _1465_/Y sky130_fd_sc_hd__a21oi_1
X_1534_ VPWR VGND VGND VPWR _1911_/D _1534_/B _1916_/D sky130_fd_sc_hd__nor2_1
X_1603_ VGND VPWR VPWR VGND _1803_/D _1613_/B _1855_/Q sky130_fd_sc_hd__and2_0
X_2017_ VPWR VGND _2017_/X _2017_/A VPWR VGND sky130_fd_sc_hd__buf_2
X_1396_ VGND VPWR VPWR VGND _1750_/D _1528_/B _1850_/Q sky130_fd_sc_hd__and2_0
XFILLER_50_253 VGND VPWR VPWR VGND sky130_fd_sc_hd__decap_12
XFILLER_2_305 VPWR VGND VPWR VGND sky130_fd_sc_hd__decap_3
XFILLER_37_98 VGND VPWR VPWR VGND sky130_fd_sc_hd__decap_12
XFILLER_41_297 VPWR VGND VPWR VGND sky130_fd_sc_hd__decap_8
XFILLER_68_117 VPWR VGND VPWR VGND sky130_fd_sc_hd__decap_8
XFILLER_5_176 VPWR VGND VPWR VGND sky130_fd_sc_hd__decap_8
XFILLER_5_165 VPWR VGND VPWR VGND sky130_fd_sc_hd__decap_3
X_1181_ VGND VPWR VGND VPWR _1177_/Y _1179_/Y _1868_/D _1180_/Y sky130_fd_sc_hd__o21ai_0
X_1250_ VGND VPWR VPWR VGND _1250_/X _2020_/A _1253_/S _1981_/Q sky130_fd_sc_hd__mux2_1
XFILLER_1_393 VGND VPWR VPWR VGND sky130_fd_sc_hd__decap_12
XFILLER_24_209 VPWR VGND VPWR VGND sky130_fd_sc_hd__decap_6
XFILLER_32_253 VGND VPWR VPWR VGND sky130_fd_sc_hd__decap_12
X_0965_ VGND VPWR _0965_/B _0965_/Y _0965_/A VPWR VGND sky130_fd_sc_hd__xnor2_1
X_0896_ VPWR VGND VGND VPWR _0976_/A _0981_/A _1877_/Q _0896_/B sky130_fd_sc_hd__maj3_1
X_1517_ VPWR VGND VGND VPWR hold416/X _1518_/B _2020_/A _1521_/S sky130_fd_sc_hd__mux2i_1
X_1448_ VGND VPWR VPWR VGND _1695_/D _1448_/B _1843_/Q sky130_fd_sc_hd__and2_0
XFILLER_70_359 VGND VPWR VPWR VGND sky130_fd_sc_hd__decap_4
X_1379_ VGND VPWR VPWR VGND _1768_/D _1529_/B _1852_/Q sky130_fd_sc_hd__and2_0
XFILLER_48_64 VPWR VGND VPWR VGND sky130_fd_sc_hd__decap_3
XFILLER_46_301 VGND VPWR VPWR VGND sky130_fd_sc_hd__decap_4
XFILLER_61_337 VPWR VGND VPWR VGND sky130_fd_sc_hd__decap_8
XFILLER_14_253 VGND VPWR VPWR VGND sky130_fd_sc_hd__decap_4
X_1302_ VGND VPWR VGND VPWR _1302_/B _1302_/D _1302_/Y _1302_/A _1302_/C sky130_fd_sc_hd__nor4_2
X_1233_ VGND VPWR VPWR VGND _1849_/D _1489_/A1 _1238_/S _1984_/Q sky130_fd_sc_hd__mux2_1
XFILLER_64_197 VPWR VGND VPWR VGND sky130_fd_sc_hd__decap_6
XFILLER_64_164 VPWR VGND VPWR VGND sky130_fd_sc_hd__decap_8
X_1164_ VGND VPWR VPWR VGND _1165_/B _1183_/B _1183_/A sky130_fd_sc_hd__and2_0
X_1095_ VGND VPWR VPWR VGND _1886_/D _1093_/X _1826_/Q _1094_/X sky130_fd_sc_hd__mux2_1
X_0948_ VPWR VGND VGND VPWR _1367_/A1 _0943_/Y _1988_/D _0947_/Y _0945_/Y _0946_/Y
+ sky130_fd_sc_hd__o221ai_1
X_1997_ _1997_/Q _1997_/CLK _1997_/D VPWR VGND VPWR VGND sky130_fd_sc_hd__dfxtp_2
XFILLER_20_212 VPWR VGND VPWR VGND sky130_fd_sc_hd__decap_6
XFILLER_20_289 VPWR VGND VPWR VGND sky130_fd_sc_hd__decap_6
X_0879_ VGND VPWR _0879_/B _0906_/B _1927_/Q VPWR VGND sky130_fd_sc_hd__xnor2_1
XFILLER_34_66 VPWR VGND VPWR VGND sky130_fd_sc_hd__decap_8
XFILLER_50_76 VPWR VGND VPWR VGND sky130_fd_sc_hd__decap_8
XFILLER_59_30 VPWR VGND VPWR VGND sky130_fd_sc_hd__decap_8
XFILLER_46_197 VGND VPWR VPWR VGND sky130_fd_sc_hd__decap_12
XFILLER_46_153 VPWR VGND VPWR VGND sky130_fd_sc_hd__decap_3
XFILLER_19_389 VPWR VGND VPWR VGND sky130_fd_sc_hd__decap_3
X_1851_ VPWR VGND _2000_/CLK _1663_/Y _1851_/Q _1851_/D VPWR VGND sky130_fd_sc_hd__edfxtp_1
X_1920_ VPWR VGND _1979_/CLK _2008_/DE _1920_/Q _1920_/D VPWR VGND sky130_fd_sc_hd__edfxtp_1
X_1782_ VPWR VGND _2001_/CLK _1790_/DE _1782_/Q _1782_/D VPWR VGND sky130_fd_sc_hd__edfxtp_1
X_1216_ VPWR VGND VGND VPWR _1875_/D _1216_/Y _1221_/B sky130_fd_sc_hd__nand2_1
XFILLER_29_109 VPWR VGND VPWR VGND sky130_fd_sc_hd__decap_3
X_1147_ VPWR VGND VGND VPWR _1941_/Q _1147_/Y _1953_/Q sky130_fd_sc_hd__nand2_1
XFILLER_1_81 VGND VPWR VPWR VGND sky130_fd_sc_hd__decap_12
X_1078_ VGND VPWR VGND VPWR _1083_/S0 _1712_/Q _1696_/Q _1083_/S1 _1728_/Q _1744_/Q
+ _1078_/X sky130_fd_sc_hd__mux4_2
XFILLER_71_421 VGND VPWR VPWR VGND sky130_fd_sc_hd__decap_4
XFILLER_28_197 VPWR VGND VPWR VGND sky130_fd_sc_hd__decap_6
XFILLER_6_15 VGND VPWR VPWR VGND sky130_fd_sc_hd__decap_12
XFILLER_62_421 VGND VPWR VPWR VGND sky130_fd_sc_hd__decap_4
X_1001_ VPWR VGND VGND VPWR _1960_/Q _1353_/C _1961_/Q sky130_fd_sc_hd__nand2_1
XFILLER_34_178 VGND VPWR VPWR VGND sky130_fd_sc_hd__decap_4
X_1834_ VPWR VGND _1967_/CLK _1926_/DE _1834_/Q _1834_/D VPWR VGND sky130_fd_sc_hd__edfxtp_1
X_1765_ VPWR VGND _1925_/CLK _1770_/DE _1765_/Q _1765_/D VPWR VGND sky130_fd_sc_hd__edfxtp_1
X_1903_ VPWR VGND _2001_/CLK _1637_/Y _2038_/A _1903_/D VPWR VGND sky130_fd_sc_hd__edfxtp_1
X_1696_ VPWR VGND _1807_/CLK _1708_/DE _1696_/Q _1696_/D VPWR VGND sky130_fd_sc_hd__edfxtp_1
XFILLER_57_237 VGND VPWR VPWR VGND sky130_fd_sc_hd__decap_4
XFILLER_40_137 VPWR VGND VPWR VGND sky130_fd_sc_hd__decap_3
XFILLER_15_57 VPWR VGND VPWR VGND sky130_fd_sc_hd__decap_3
XFILLER_0_277 VPWR VGND VPWR VGND sky130_fd_sc_hd__decap_3
XFILLER_71_240 VGND VPWR VPWR VGND sky130_fd_sc_hd__decap_4
XFILLER_44_421 VGND VPWR VPWR VGND sky130_fd_sc_hd__decap_4
Xplace207 VPWR VGND _2015_/DE _1932_/DE VPWR VGND sky130_fd_sc_hd__buf_2
Xplace218 VPWR VGND _1726_/DE _1282_/Y VPWR VGND sky130_fd_sc_hd__buf_2
XFILLER_16_123 VPWR VGND VPWR VGND sky130_fd_sc_hd__decap_3
Xplace229 VPWR VGND _1402_/B _1528_/B VPWR VGND sky130_fd_sc_hd__buf_2
XFILLER_8_333 VGND VPWR VPWR VGND sky130_fd_sc_hd__decap_12
XFILLER_8_377 VGND VPWR VPWR VGND sky130_fd_sc_hd__decap_12
X_1550_ VPWR VGND VGND VPWR _2027_/A _1546_/Y _1549_/Y _1975_/D sky130_fd_sc_hd__o21a_1
X_1481_ VPWR VGND VGND VPWR _1958_/Q _1689_/B _1481_/A1 _1584_/S sky130_fd_sc_hd__mux2i_1
XFILLER_54_218 VPWR VGND VPWR VGND sky130_fd_sc_hd__decap_3
X_2033_ VPWR VGND _2033_/X _2033_/A VPWR VGND sky130_fd_sc_hd__buf_2
XFILLER_11_3 VGND VPWR VPWR VGND sky130_fd_sc_hd__decap_12
XFILLER_62_240 VGND VPWR VPWR VGND sky130_fd_sc_hd__decap_12
XFILLER_50_413 VPWR VGND VPWR VGND sky130_fd_sc_hd__decap_6
XFILLER_22_137 VPWR VGND VPWR VGND sky130_fd_sc_hd__decap_3
Xhold344 _1913_/D _1911_/Q VPWR VGND VGND VPWR sky130_fd_sc_hd__dlygate4sd3_1
X_1817_ VPWR VGND clkload6/A _1817_/DE _1817_/Q _1817_/D VPWR VGND sky130_fd_sc_hd__edfxtp_1
X_1748_ VPWR VGND _1749_/CLK _1754_/DE _1748_/Q _1748_/D VPWR VGND sky130_fd_sc_hd__edfxtp_1
Xhold388 _1609_/A _1870_/Q VPWR VGND VGND VPWR sky130_fd_sc_hd__dlygate4sd3_1
Xhold366 _1830_/D _1912_/Q VPWR VGND VGND VPWR sky130_fd_sc_hd__dlygate4sd3_1
Xhold399 _1838_/D _1943_/Q VPWR VGND VGND VPWR sky130_fd_sc_hd__dlygate4sd3_1
X_1679_ VPWR VGND VGND VPWR _1679_/A _1679_/Y sky130_fd_sc_hd__inv_1
Xhold355 _1909_/D _2016_/Q VPWR VGND VGND VPWR sky130_fd_sc_hd__dlygate4sd3_1
Xhold377 _2010_/D _1816_/Q VPWR VGND VGND VPWR sky130_fd_sc_hd__dlygate4sd3_1
XFILLER_26_421 VGND VPWR VPWR VGND sky130_fd_sc_hd__decap_4
XFILLER_42_22 VPWR VGND VPWR VGND sky130_fd_sc_hd__decap_6
XFILLER_3_27 VGND VPWR VPWR VGND sky130_fd_sc_hd__decap_12
XFILLER_29_281 VPWR VGND VPWR VGND sky130_fd_sc_hd__decap_6
X_0981_ VGND VPWR _0981_/B _0981_/Y _0981_/A VPWR VGND sky130_fd_sc_hd__xnor2_1
X_1602_ VPWR VGND VGND VPWR _1679_/A _1602_/B _1964_/D sky130_fd_sc_hd__nor2_1
XFILLER_59_3 VGND VPWR VPWR VGND sky130_fd_sc_hd__decap_12
XFILLER_8_141 VPWR VGND VPWR VGND sky130_fd_sc_hd__decap_8
XFILLER_12_181 VGND VPWR VPWR VGND sky130_fd_sc_hd__decap_4
XFILLER_67_343 VPWR VGND VPWR VGND sky130_fd_sc_hd__decap_3
X_1464_ VPWR VGND VPWR VGND _1521_/S _1463_/Y _1464_/Y _1861_/Q _1459_/B sky130_fd_sc_hd__a22oi_1
X_1533_ VPWR VGND VGND VPWR _1958_/Q _1538_/B _1534_/B sky130_fd_sc_hd__nor2_1
X_1395_ VGND VPWR VPWR VGND _1751_/D _1528_/B _1851_/Q sky130_fd_sc_hd__and2_0
X_2016_ VPWR VGND _2016_/CLK _2016_/DE _2016_/Q _2016_/D VPWR VGND sky130_fd_sc_hd__edfxtp_1
XFILLER_23_402 VGND VPWR VPWR VGND sky130_fd_sc_hd__decap_12
XFILLER_50_265 VPWR VGND VPWR VGND sky130_fd_sc_hd__decap_8
Xclkbuf_leaf_30_clk _1807_/CLK clkbuf_3_4__f_clk/X VPWR VGND VGND VPWR sky130_fd_sc_hd__clkbuf_8
XFILLER_58_398 VGND VPWR VPWR VGND sky130_fd_sc_hd__decap_12
XFILLER_58_365 VPWR VGND VPWR VGND sky130_fd_sc_hd__decap_6
XFILLER_53_65 VGND VPWR VPWR VGND sky130_fd_sc_hd__decap_12
XFILLER_53_98 VGND VPWR VPWR VGND sky130_fd_sc_hd__decap_4
Xclkbuf_leaf_21_clk _1979_/CLK clkload0/A VPWR VGND VGND VPWR sky130_fd_sc_hd__clkbuf_8
XFILLER_1_361 VGND VPWR VPWR VGND sky130_fd_sc_hd__decap_12
XFILLER_64_379 VPWR VGND VPWR VGND sky130_fd_sc_hd__decap_6
X_1180_ VGND VPWR VGND VPWR _1207_/B _1957_/Q _1180_/Y _1339_/A1 sky130_fd_sc_hd__o21ai_0
X_0964_ VGND VPWR VGND VPWR _0963_/X _0992_/A _1985_/D _0960_/Y sky130_fd_sc_hd__o21ai_0
Xclkbuf_leaf_12_clk _1997_/CLK clkbuf_leaf_4_clk/A VPWR VGND VGND VPWR sky130_fd_sc_hd__clkbuf_8
XFILLER_32_265 VPWR VGND VPWR VGND sky130_fd_sc_hd__decap_6
X_1516_ VPWR VGND VGND VPWR _1522_/A _1516_/B _1940_/D sky130_fd_sc_hd__nor2_1
X_0895_ VGND VPWR VPWR VGND _1877_/Q _0981_/B _0896_/B sky130_fd_sc_hd__xor2_1
X_1378_ VGND VPWR VPWR VGND _1769_/D _1529_/B _1853_/Q sky130_fd_sc_hd__and2_0
X_1447_ VGND VPWR VPWR VGND _1696_/D _1448_/B _1844_/Q sky130_fd_sc_hd__and2_0
XFILLER_11_405 VGND VPWR VPWR VGND sky130_fd_sc_hd__decap_12
XFILLER_23_57 VGND VPWR VPWR VGND sky130_fd_sc_hd__decap_4
XFILLER_48_21 VPWR VGND VPWR VGND sky130_fd_sc_hd__decap_6
Xfanout91 VPWR VGND _1689_/A _1694_/A VPWR VGND sky130_fd_sc_hd__buf_2
XFILLER_9_15 VGND VPWR VPWR VGND sky130_fd_sc_hd__decap_12
XFILLER_69_405 VGND VPWR VPWR VGND sky130_fd_sc_hd__decap_12
X_1301_ VGND VPWR VPWR VGND _1959_/Q _1302_/D _1873_/Q sky130_fd_sc_hd__xor2_1
XFILLER_49_162 VPWR VGND VPWR VGND sky130_fd_sc_hd__decap_6
X_1232_ VGND VPWR VPWR VGND _1850_/D _1487_/A1 _1238_/S _1985_/Q sky130_fd_sc_hd__mux2_1
Xclkbuf_leaf_1_clk _2015_/CLK clkbuf_leaf_2_clk/A VPWR VGND VGND VPWR sky130_fd_sc_hd__clkbuf_8
XFILLER_64_121 VPWR VGND VPWR VGND sky130_fd_sc_hd__decap_8
X_1163_ VPWR VGND VPWR VGND _1162_/Y _1142_/Y _1143_/Y _1183_/B sky130_fd_sc_hd__a21oi_1
X_1094_ VGND VPWR VGND VPWR _1261_/S1 _1755_/Q _1723_/Q _1261_/S0 _1787_/Q _1819_/Q
+ _1094_/X sky130_fd_sc_hd__mux4_2
X_0947_ VPWR VGND VGND VPWR _0974_/A _0947_/Y _0947_/B sky130_fd_sc_hd__nand2_1
X_1996_ _1996_/Q _1997_/CLK _1996_/D VPWR VGND VPWR VGND sky130_fd_sc_hd__dfxtp_1
XFILLER_20_224 VPWR VGND VPWR VGND sky130_fd_sc_hd__decap_8
X_0878_ VGND VPWR _0878_/B _0908_/B _1928_/Q VPWR VGND sky130_fd_sc_hd__xnor2_1
XFILLER_18_24 VGND VPWR VPWR VGND sky130_fd_sc_hd__decap_4
XFILLER_51_393 VPWR VGND VPWR VGND sky130_fd_sc_hd__decap_8
XFILLER_43_327 VPWR VGND VPWR VGND sky130_fd_sc_hd__decap_8
Xclkload0 clkload0/X clkload0/A VPWR VGND VGND VPWR sky130_fd_sc_hd__clkbuf_8
XFILLER_7_217 VPWR VGND VPWR VGND sky130_fd_sc_hd__decap_6
XFILLER_61_113 VGND VPWR VPWR VGND sky130_fd_sc_hd__decap_4
XFILLER_46_176 VPWR VGND VPWR VGND sky130_fd_sc_hd__decap_3
X_1850_ VPWR VGND _1925_/CLK _1664_/Y _1850_/Q _1850_/D VPWR VGND sky130_fd_sc_hd__edfxtp_1
X_1781_ VPWR VGND _1925_/CLK _1786_/DE _1781_/Q _1781_/D VPWR VGND sky130_fd_sc_hd__edfxtp_1
XFILLER_69_246 VGND VPWR VPWR VGND sky130_fd_sc_hd__decap_4
X_1146_ VPWR VGND VGND VPWR _1146_/A _1146_/B _1193_/A sky130_fd_sc_hd__nor2_1
X_1215_ VGND VPWR VGND VPWR _1214_/Y _1218_/A _1861_/D _1213_/Y sky130_fd_sc_hd__o21ai_0
XFILLER_52_102 VGND VPWR VPWR VGND sky130_fd_sc_hd__decap_4
X_1077_ VPWR VGND VGND VPWR _1219_/A _1077_/Y _1085_/B sky130_fd_sc_hd__nand2_1
XFILLER_33_393 VPWR VGND VPWR VGND sky130_fd_sc_hd__decap_3
XFILLER_1_93 VGND VPWR VPWR VGND sky130_fd_sc_hd__decap_12
X_1979_ VPWR VGND _1979_/CLK _1687_/Y _1979_/Q _1979_/D VPWR VGND sky130_fd_sc_hd__edfxtp_1
XFILLER_4_209 VGND VPWR VPWR VGND sky130_fd_sc_hd__decap_12
XFILLER_43_113 VPWR VGND VPWR VGND sky130_fd_sc_hd__decap_8
XFILLER_16_349 VGND VPWR VPWR VGND sky130_fd_sc_hd__decap_12
XFILLER_61_98 VPWR VGND VPWR VGND sky130_fd_sc_hd__decap_6
X_1000_ VPWR VGND VGND VPWR _0838_/Y _1831_/Q _1978_/D _0999_/Y _0998_/Y _0992_/A
+ sky130_fd_sc_hd__o221ai_1
XFILLER_19_121 VGND VPWR VPWR VGND sky130_fd_sc_hd__decap_12
X_1902_ VPWR VGND _2009_/CLK _1638_/Y _2037_/A _1902_/D VPWR VGND sky130_fd_sc_hd__edfxtp_1
X_1833_ VPWR VGND _1967_/CLK _1926_/DE _1833_/Q _1833_/D VPWR VGND sky130_fd_sc_hd__edfxtp_1
X_1764_ VPWR VGND _1995_/CLK _1770_/DE _1764_/Q _1764_/D VPWR VGND sky130_fd_sc_hd__edfxtp_1
X_1695_ VPWR VGND _1749_/CLK _1708_/DE _1695_/Q _1695_/D VPWR VGND sky130_fd_sc_hd__edfxtp_1
XFILLER_65_260 VPWR VGND VPWR VGND sky130_fd_sc_hd__decap_8
X_1129_ VGND VPWR VGND VPWR _1130_/S0 _1727_/Q _1695_/Q _1130_/S1 _1759_/Q _1791_/Q
+ _1129_/X sky130_fd_sc_hd__mux4_2
XFILLER_31_57 VGND VPWR VPWR VGND sky130_fd_sc_hd__decap_12
Xplace208 VPWR VGND _2016_/DE _1932_/DE VPWR VGND sky130_fd_sc_hd__buf_2
Xplace219 VPWR VGND _1433_/B _1526_/B VPWR VGND sky130_fd_sc_hd__buf_2
XFILLER_16_135 VGND VPWR VPWR VGND sky130_fd_sc_hd__decap_4
XPHY_EDGE_ROW_19_Right_19 VPWR VGND VPWR VGND sky130_fd_sc_hd__decap_3
XFILLER_8_301 VPWR VGND VPWR VGND sky130_fd_sc_hd__decap_6
XFILLER_8_345 VGND VPWR VPWR VGND sky130_fd_sc_hd__decap_12
XFILLER_8_389 VGND VPWR VPWR VGND sky130_fd_sc_hd__decap_12
Xclkbuf_3_1__f_clk VGND VPWR VGND VPWR clkbuf_0_clk/X clkbuf_3_1__f_clk/X sky130_fd_sc_hd__clkbuf_16
X_1480_ VPWR VGND VGND VPWR _1689_/A _1480_/B _1960_/D sky130_fd_sc_hd__nor2_1
XFILLER_39_216 VPWR VGND VPWR VGND sky130_fd_sc_hd__decap_3
XPHY_EDGE_ROW_28_Right_28 VPWR VGND VPWR VGND sky130_fd_sc_hd__decap_3
XPHY_EDGE_ROW_37_Right_37 VPWR VGND VPWR VGND sky130_fd_sc_hd__decap_3
X_2032_ VPWR VGND _2032_/X _2032_/A VPWR VGND sky130_fd_sc_hd__buf_2
Xhold378 _1831_/D _1936_/Q VPWR VGND VGND VPWR sky130_fd_sc_hd__dlygate4sd3_1
X_1678_ VPWR VGND VGND VPWR _1679_/A _1678_/Y sky130_fd_sc_hd__inv_1
XPHY_EDGE_ROW_46_Right_46 VPWR VGND VPWR VGND sky130_fd_sc_hd__decap_3
X_1747_ VPWR VGND _1925_/CLK _1754_/DE _1747_/Q _1747_/D VPWR VGND sky130_fd_sc_hd__edfxtp_1
Xhold345 _1900_/D _2007_/Q VPWR VGND VGND VPWR sky130_fd_sc_hd__dlygate4sd3_1
XFILLER_7_81 VPWR VGND VPWR VGND sky130_fd_sc_hd__decap_6
X_1816_ VPWR VGND clkload5/A _1817_/DE _1816_/Q _1816_/D VPWR VGND sky130_fd_sc_hd__edfxtp_1
XPHY_EDGE_ROW_15_Left_87 VPWR VGND VPWR VGND sky130_fd_sc_hd__decap_3
Xhold367 _2004_/D _1810_/Q VPWR VGND VGND VPWR sky130_fd_sc_hd__dlygate4sd3_1
Xhold356 _1896_/D _2003_/Q VPWR VGND VGND VPWR sky130_fd_sc_hd__dlygate4sd3_1
Xhold389 _1840_/D _1945_/Q VPWR VGND VGND VPWR sky130_fd_sc_hd__dlygate4sd3_1
XPHY_EDGE_ROW_55_Right_55 VPWR VGND VPWR VGND sky130_fd_sc_hd__decap_3
XFILLER_26_411 VPWR VGND VPWR VGND sky130_fd_sc_hd__decap_8
XPHY_EDGE_ROW_64_Right_64 VPWR VGND VPWR VGND sky130_fd_sc_hd__decap_3
XFILLER_5_337 VGND VPWR VPWR VGND sky130_fd_sc_hd__decap_12
XFILLER_3_39 VGND VPWR VPWR VGND sky130_fd_sc_hd__decap_12
XFILLER_67_86 VGND VPWR VPWR VGND sky130_fd_sc_hd__decap_12
XFILLER_44_241 VPWR VGND VPWR VGND sky130_fd_sc_hd__decap_8
XFILLER_29_293 VPWR VGND VPWR VGND sky130_fd_sc_hd__decap_6
X_0980_ VGND VPWR VGND VPWR _0979_/X _0992_/A _1982_/D _0976_/Y sky130_fd_sc_hd__o21ai_0
XFILLER_32_403 VGND VPWR VPWR VGND sky130_fd_sc_hd__decap_12
X_1601_ VPWR VGND VPWR VGND _1327_/Y hold403/X _1584_/S _1602_/B sky130_fd_sc_hd__a21oi_1
XFILLER_8_197 VPWR VGND VPWR VGND sky130_fd_sc_hd__decap_8
X_1532_ VGND VPWR VPWR VGND _1822_/D _1598_/B _1858_/Q sky130_fd_sc_hd__and2_0
X_1463_ VPWR VGND VGND VPWR _1463_/A _1576_/B _1463_/Y sky130_fd_sc_hd__nor2_1
X_1394_ VGND VPWR VPWR VGND _1752_/D _1528_/B _1852_/Q sky130_fd_sc_hd__and2_0
X_2015_ VPWR VGND _2015_/CLK _2015_/DE _2015_/Q _2015_/D VPWR VGND sky130_fd_sc_hd__edfxtp_1
XFILLER_27_219 VGND VPWR VPWR VGND sky130_fd_sc_hd__decap_4
XFILLER_23_414 VGND VPWR VPWR VGND sky130_fd_sc_hd__decap_12
XFILLER_12_15 VGND VPWR VPWR VGND sky130_fd_sc_hd__decap_12
XFILLER_58_355 VPWR VGND VPWR VGND sky130_fd_sc_hd__decap_8
XFILLER_58_322 VGND VPWR VPWR VGND sky130_fd_sc_hd__decap_4
XFILLER_53_11 VGND VPWR VPWR VGND sky130_fd_sc_hd__decap_12
XFILLER_49_311 VGND VPWR VPWR VGND sky130_fd_sc_hd__decap_4
XFILLER_1_373 VGND VPWR VPWR VGND sky130_fd_sc_hd__decap_12
XFILLER_71_3 VGND VPWR VPWR VGND sky130_fd_sc_hd__decap_12
X_0963_ VPWR VGND VPWR VGND _0963_/X _0838_/Y _0957_/B _0962_/Y _0857_/A _0961_/Y
+ sky130_fd_sc_hd__o32a_1
X_0894_ VPWR VGND VGND VPWR _0981_/A _0986_/A _1876_/Q _0894_/B sky130_fd_sc_hd__maj3_1
X_1515_ VPWR VGND VGND VPWR _1835_/D _1516_/B _2021_/A _1521_/S sky130_fd_sc_hd__mux2i_1
XFILLER_67_185 VGND VPWR VPWR VGND sky130_fd_sc_hd__decap_4
X_1377_ VGND VPWR VPWR VGND _1770_/D _1386_/B _1854_/Q sky130_fd_sc_hd__and2_0
X_1446_ VGND VPWR VPWR VGND _1697_/D _1448_/B _1845_/Q sky130_fd_sc_hd__and2_0
XFILLER_11_417 VPWR VGND VPWR VGND sky130_fd_sc_hd__decap_8
XPHY_EDGE_ROW_36_Left_108 VPWR VGND VPWR VGND sky130_fd_sc_hd__decap_3
XFILLER_58_141 VGND VPWR VPWR VGND sky130_fd_sc_hd__decap_4
XPHY_EDGE_ROW_45_Left_117 VPWR VGND VPWR VGND sky130_fd_sc_hd__decap_3
XPHY_EDGE_ROW_18_Left_90 VPWR VGND VPWR VGND sky130_fd_sc_hd__decap_3
XFILLER_46_358 VPWR VGND VPWR VGND sky130_fd_sc_hd__decap_6
XFILLER_0_29 VGND VPWR VPWR VGND sky130_fd_sc_hd__decap_12
XPHY_EDGE_ROW_54_Left_126 VPWR VGND VPWR VGND sky130_fd_sc_hd__decap_3
Xfanout92 VGND VPWR _1691_/A _1694_/A VPWR VGND sky130_fd_sc_hd__clkdlybuf4s15_1
XFILLER_9_27 VGND VPWR VPWR VGND sky130_fd_sc_hd__decap_12
XFILLER_14_288 VGND VPWR VPWR VGND sky130_fd_sc_hd__decap_12
XFILLER_69_417 VPWR VGND VPWR VGND sky130_fd_sc_hd__decap_8
XFILLER_6_421 VGND VPWR VPWR VGND sky130_fd_sc_hd__decap_4
XPHY_EDGE_ROW_63_Left_135 VPWR VGND VPWR VGND sky130_fd_sc_hd__decap_3
X_1162_ VPWR VGND VPWR VGND _1193_/B _1193_/A _1146_/A _1162_/Y sky130_fd_sc_hd__a21oi_1
X_1300_ VGND VPWR VPWR VGND _1957_/Q _1302_/C _1871_/Q sky130_fd_sc_hd__xor2_1
X_1231_ VGND VPWR VPWR VGND _1851_/D _1485_/A1 _1349_/S _1986_/Q sky130_fd_sc_hd__mux2_1
XFILLER_1_181 VGND VPWR VPWR VGND sky130_fd_sc_hd__decap_12
X_1093_ VGND VPWR VGND VPWR _1261_/S1 _1739_/Q _1707_/Q _1261_/S0 _1771_/Q _1803_/Q
+ _1093_/X sky130_fd_sc_hd__mux4_2
X_0946_ VPWR VGND VGND VPWR _1841_/Q _0946_/B _0946_/Y sky130_fd_sc_hd__nor2_1
X_0877_ VGND VPWR _0877_/B _0910_/B _1929_/Q VPWR VGND sky130_fd_sc_hd__xnor2_1
X_1995_ _1995_/Q _1995_/CLK _1995_/D VPWR VGND VPWR VGND sky130_fd_sc_hd__dfxtp_2
XFILLER_9_270 VPWR VGND VPWR VGND sky130_fd_sc_hd__decap_8
XFILLER_9_281 VGND VPWR VPWR VGND sky130_fd_sc_hd__decap_12
X_1429_ VGND VPWR VPWR VGND _1715_/D _1433_/B _1847_/Q sky130_fd_sc_hd__and2_0
XFILLER_43_306 VPWR VGND VPWR VGND sky130_fd_sc_hd__decap_6
XFILLER_28_347 VGND VPWR VPWR VGND sky130_fd_sc_hd__decap_4
XFILLER_18_69 VGND VPWR VPWR VGND sky130_fd_sc_hd__decap_12
XFILLER_50_23 VGND VPWR VPWR VGND sky130_fd_sc_hd__decap_4
Xclkload1 VGND VPWR clkload1/A clkload1/X VPWR VGND sky130_fd_sc_hd__clkbuf_4
XFILLER_7_229 VPWR VGND VPWR VGND sky130_fd_sc_hd__decap_3
XFILLER_11_225 VGND VPWR VPWR VGND sky130_fd_sc_hd__decap_12
XFILLER_1_3 VGND VPWR VPWR VGND sky130_fd_sc_hd__decap_12
XPHY_EDGE_ROW_3_Left_75 VPWR VGND VPWR VGND sky130_fd_sc_hd__decap_3
X_1780_ VPWR VGND _1925_/CLK _1786_/DE _1780_/Q _1780_/D VPWR VGND sky130_fd_sc_hd__edfxtp_1
XFILLER_69_225 VPWR VGND VPWR VGND sky130_fd_sc_hd__decap_3
XFILLER_6_295 VGND VPWR VPWR VGND sky130_fd_sc_hd__decap_12
X_1145_ VPWR VGND VGND VPWR _1942_/Q _1309_/A _1146_/B sky130_fd_sc_hd__nor2_1
X_1214_ VPWR VGND VPWR VGND _1157_/B _1218_/A _1214_/Y _1876_/D _1221_/B sky130_fd_sc_hd__a22oi_1
XFILLER_60_191 VGND VPWR VPWR VGND sky130_fd_sc_hd__decap_4
X_1076_ VGND VPWR VGND VPWR _1075_/Y _1086_/A1 _1921_/D _1074_/Y sky130_fd_sc_hd__o21ai_0
X_1978_ VPWR VGND _1984_/CLK _1688_/Y _1978_/Q _1978_/D VPWR VGND sky130_fd_sc_hd__edfxtp_1
X_0929_ VPWR VGND VPWR VGND _1885_/Q _1997_/Q _0945_/A1 _0929_/X sky130_fd_sc_hd__a21o_1
XFILLER_20_15 VGND VPWR VPWR VGND sky130_fd_sc_hd__decap_12
XFILLER_29_57 VPWR VGND VPWR VGND sky130_fd_sc_hd__decap_8
XFILLER_0_405 VGND VPWR VPWR VGND sky130_fd_sc_hd__decap_12
XFILLER_45_23 VPWR VGND VPWR VGND sky130_fd_sc_hd__decap_3
XFILLER_43_169 VGND VPWR VPWR VGND sky130_fd_sc_hd__decap_4
XFILLER_43_103 VPWR VGND VPWR VGND sky130_fd_sc_hd__decap_8
XFILLER_66_217 VPWR VGND VPWR VGND sky130_fd_sc_hd__decap_6
XFILLER_19_133 VGND VPWR VPWR VGND sky130_fd_sc_hd__decap_4
XFILLER_19_199 VGND VPWR VPWR VGND sky130_fd_sc_hd__decap_12
X_1832_ VPWR VGND _1967_/CLK _1926_/DE _1832_/Q _1832_/D VPWR VGND sky130_fd_sc_hd__edfxtp_1
XFILLER_42_180 VGND VPWR VPWR VGND sky130_fd_sc_hd__decap_4
X_1901_ VPWR VGND _2008_/CLK _1639_/Y _2036_/A _1901_/D VPWR VGND sky130_fd_sc_hd__edfxtp_1
XFILLER_22_309 VPWR VGND VPWR VGND sky130_fd_sc_hd__decap_8
X_1694_ VPWR VGND VGND VPWR _1694_/A _1694_/Y sky130_fd_sc_hd__inv_1
X_1763_ VPWR VGND _1954_/CLK _1770_/DE _1763_/Q _1763_/D VPWR VGND sky130_fd_sc_hd__edfxtp_1
X_1059_ VGND VPWR VGND VPWR _1059_/S0 _1780_/Q _1764_/Q _1064_/S1 _1796_/Q _1812_/Q
+ _1059_/X sky130_fd_sc_hd__mux4_2
XFILLER_15_15 VGND VPWR VPWR VGND sky130_fd_sc_hd__decap_12
X_1128_ VGND VPWR VPWR VGND _1875_/D _1126_/X _1131_/S _1127_/X sky130_fd_sc_hd__mux2_1
XFILLER_25_103 VPWR VGND VPWR VGND sky130_fd_sc_hd__decap_8
XFILLER_25_169 VGND VPWR VPWR VGND sky130_fd_sc_hd__decap_12
XFILLER_21_375 VGND VPWR VPWR VGND sky130_fd_sc_hd__decap_12
XFILLER_31_69 VPWR VGND VPWR VGND sky130_fd_sc_hd__decap_8
Xplace209 VPWR VGND _1932_/DE _1358_/D VPWR VGND sky130_fd_sc_hd__buf_2
XFILLER_71_275 VGND VPWR VPWR VGND sky130_fd_sc_hd__decap_4
XFILLER_71_253 VGND VPWR VPWR VGND sky130_fd_sc_hd__decap_12
XFILLER_71_220 VGND VPWR VPWR VGND sky130_fd_sc_hd__decap_4
XFILLER_8_357 VPWR VGND VPWR VGND sky130_fd_sc_hd__decap_6
XFILLER_54_209 VGND VPWR VPWR VGND sky130_fd_sc_hd__decap_4
X_2031_ VPWR VGND _2031_/X _2031_/A VPWR VGND sky130_fd_sc_hd__buf_2
X_1815_ VPWR VGND _2009_/CLK _1266_/X _1815_/Q _1815_/D VPWR VGND sky130_fd_sc_hd__edfxtp_1
XFILLER_22_117 VGND VPWR VPWR VGND sky130_fd_sc_hd__decap_12
Xhold368 _1837_/D _1942_/Q VPWR VGND VGND VPWR sky130_fd_sc_hd__dlygate4sd3_1
X_1677_ VPWR VGND VGND VPWR _1679_/A _1677_/Y sky130_fd_sc_hd__inv_1
Xhold357 _1908_/D _2015_/Q VPWR VGND VGND VPWR sky130_fd_sc_hd__dlygate4sd3_1
Xhold379 _2001_/D _1807_/Q VPWR VGND VGND VPWR sky130_fd_sc_hd__dlygate4sd3_1
Xhold346 _1895_/D _2002_/Q VPWR VGND VGND VPWR sky130_fd_sc_hd__dlygate4sd3_1
X_1746_ VPWR VGND _1777_/CLK _1754_/DE _1746_/Q _1746_/D VPWR VGND sky130_fd_sc_hd__edfxtp_1
XFILLER_5_349 VGND VPWR VPWR VGND sky130_fd_sc_hd__decap_12
XFILLER_21_183 VGND VPWR VPWR VGND sky130_fd_sc_hd__decap_4
XFILLER_67_98 VGND VPWR VPWR VGND sky130_fd_sc_hd__decap_12
XFILLER_44_253 VGND VPWR VPWR VGND sky130_fd_sc_hd__decap_4
XFILLER_32_415 VGND VPWR VPWR VGND sky130_fd_sc_hd__decap_4
XFILLER_17_401 VGND VPWR VPWR VGND sky130_fd_sc_hd__decap_12
X_1462_ VGND VPWR _1576_/B _2018_/A _2017_/A _2019_/A VPWR VGND sky130_fd_sc_hd__and3_1
XFILLER_8_176 VPWR VGND VPWR VGND sky130_fd_sc_hd__decap_8
X_1600_ VGND VPWR VPWR VGND _1804_/D _1613_/B _1856_/Q sky130_fd_sc_hd__and2_0
X_1531_ VGND VPWR VPWR VGND _1806_/D _1613_/B _1858_/Q sky130_fd_sc_hd__and2_0
XFILLER_67_323 VPWR VGND VPWR VGND sky130_fd_sc_hd__decap_8
X_1393_ VGND VPWR VPWR VGND _1753_/D _1402_/B _1853_/Q sky130_fd_sc_hd__and2_0
XFILLER_50_201 VPWR VGND VPWR VGND sky130_fd_sc_hd__decap_8
X_2014_ VPWR VGND clkload5/A _2016_/DE _2014_/Q _2014_/D VPWR VGND sky130_fd_sc_hd__edfxtp_1
X_1729_ VPWR VGND _1777_/CLK _1737_/DE _1729_/Q _1729_/D VPWR VGND sky130_fd_sc_hd__edfxtp_1
XFILLER_26_253 VPWR VGND VPWR VGND sky130_fd_sc_hd__decap_6
XFILLER_18_209 VPWR VGND VPWR VGND sky130_fd_sc_hd__decap_8
XFILLER_53_23 VPWR VGND VPWR VGND sky130_fd_sc_hd__decap_6
XFILLER_14_415 VGND VPWR VPWR VGND sky130_fd_sc_hd__decap_4
XFILLER_5_113 VGND VPWR VPWR VGND sky130_fd_sc_hd__decap_12
XFILLER_49_323 VPWR VGND VPWR VGND sky130_fd_sc_hd__decap_6
XFILLER_1_385 VPWR VGND VPWR VGND sky130_fd_sc_hd__decap_6
X_0962_ VGND VPWR VPWR VGND _0973_/B _1837_/Q _1836_/Q _0962_/Y _1838_/Q sky130_fd_sc_hd__a31oi_1
X_0893_ VGND VPWR VPWR VGND _1876_/Q _0986_/B _0894_/B sky130_fd_sc_hd__xor2_1
XFILLER_32_289 VPWR VGND VPWR VGND sky130_fd_sc_hd__decap_8
X_1514_ VPWR VGND VGND VPWR _1688_/A _1514_/B _1941_/D sky130_fd_sc_hd__nor2_1
XFILLER_4_190 VPWR VGND VPWR VGND sky130_fd_sc_hd__decap_6
X_1445_ VGND VPWR VPWR VGND _1698_/D _1448_/B _1846_/Q sky130_fd_sc_hd__and2_0
XFILLER_67_197 VPWR VGND VPWR VGND sky130_fd_sc_hd__decap_3
X_1376_ VGND VPWR VPWR VGND _1771_/D _1529_/B _1855_/Q sky130_fd_sc_hd__and2_0
XFILLER_58_153 VGND VPWR VPWR VGND sky130_fd_sc_hd__decap_12
XFILLER_48_56 VPWR VGND VPWR VGND sky130_fd_sc_hd__decap_8
Xfanout93 VPWR VGND _1694_/A _1673_/A VPWR VGND sky130_fd_sc_hd__buf_2
XFILLER_9_39 VGND VPWR VPWR VGND sky130_fd_sc_hd__decap_12
XFILLER_64_101 VPWR VGND VPWR VGND sky130_fd_sc_hd__decap_8
X_1161_ VPWR VGND VPWR VGND _1198_/A _1147_/Y _1148_/Y _1193_/B sky130_fd_sc_hd__a21oi_1
X_1230_ VGND VPWR VPWR VGND _1852_/D _1483_/A1 _1349_/S _1987_/Q sky130_fd_sc_hd__mux2_1
XFILLER_37_337 VGND VPWR VPWR VGND sky130_fd_sc_hd__decap_12
XFILLER_37_326 VPWR VGND VPWR VGND sky130_fd_sc_hd__decap_8
XFILLER_1_193 VGND VPWR VPWR VGND sky130_fd_sc_hd__decap_12
X_1092_ VGND VPWR VPWR VGND _1887_/D _1090_/X _1826_/Q _1091_/X sky130_fd_sc_hd__mux2_1
X_1994_ _1994_/Q _1994_/CLK _1994_/D VPWR VGND VPWR VGND sky130_fd_sc_hd__dfxtp_1
X_0945_ VGND VPWR VGND VPWR _1929_/Q _0945_/A1 _0945_/Y _0944_/X sky130_fd_sc_hd__o21ai_0
X_0876_ VPWR VGND VGND VPWR _0874_/Y _0876_/B _0912_/B sky130_fd_sc_hd__nand2b_1
XFILLER_9_293 VGND VPWR VPWR VGND sky130_fd_sc_hd__decap_12
X_1428_ VGND VPWR VPWR VGND _1716_/D _1433_/B _1848_/Q sky130_fd_sc_hd__and2_0
XFILLER_18_15 VGND VPWR VPWR VGND sky130_fd_sc_hd__decap_4
XFILLER_55_101 VPWR VGND VPWR VGND sky130_fd_sc_hd__decap_8
X_1359_ VPWR VGND VGND VPWR _0875_/A _1995_/D _1358_/Y _1357_/Y _1926_/DE sky130_fd_sc_hd__o211ai_1
XFILLER_36_381 VPWR VGND VPWR VGND sky130_fd_sc_hd__decap_8
XFILLER_51_373 VPWR VGND VPWR VGND sky130_fd_sc_hd__decap_8
XFILLER_34_58 VGND VPWR VPWR VGND sky130_fd_sc_hd__decap_4
Xclkload2 VPWR VGND VPWR VGND clkload2/Y clkload2/A sky130_fd_sc_hd__inv_6
XFILLER_11_237 VPWR VGND VPWR VGND sky130_fd_sc_hd__decap_8
XFILLER_19_337 VGND VPWR VPWR VGND sky130_fd_sc_hd__decap_12
X_1213_ VGND VPWR _1213_/B _1213_/Y _1213_/A VPWR VGND sky130_fd_sc_hd__xnor2_1
XFILLER_65_421 VGND VPWR VPWR VGND sky130_fd_sc_hd__decap_4
X_1144_ VGND VPWR VPWR VGND _1146_/A _1309_/A _1942_/Q sky130_fd_sc_hd__and2_0
X_1075_ VPWR VGND VGND VPWR _1157_/B _1075_/Y _1085_/B sky130_fd_sc_hd__nand2_1
XFILLER_1_51 VGND VPWR VPWR VGND sky130_fd_sc_hd__decap_4
X_1977_ _1977_/Q _1977_/CLK _1977_/D VPWR VGND VPWR VGND sky130_fd_sc_hd__dfxtp_1
X_0928_ VGND VPWR _0928_/B _0928_/Y _0928_/A VPWR VGND sky130_fd_sc_hd__xnor2_1
X_0859_ VPWR VGND VPWR VGND _1928_/Q _0859_/D _1929_/Q _1927_/Q _0875_/C sky130_fd_sc_hd__or4_1
XFILLER_0_417 VPWR VGND VPWR VGND sky130_fd_sc_hd__decap_3
XFILLER_56_421 VGND VPWR VPWR VGND sky130_fd_sc_hd__decap_4
XFILLER_28_112 VGND VPWR VPWR VGND sky130_fd_sc_hd__decap_12
XFILLER_45_57 VPWR VGND VPWR VGND sky130_fd_sc_hd__decap_6
XFILLER_16_329 VPWR VGND VPWR VGND sky130_fd_sc_hd__decap_3
XFILLER_6_29 VGND VPWR VPWR VGND sky130_fd_sc_hd__decap_12
X_1831_ VPWR VGND _1984_/CLK _1878_/DE _1831_/Q _1831_/D VPWR VGND sky130_fd_sc_hd__edfxtp_1
XFILLER_30_376 VGND VPWR VPWR VGND sky130_fd_sc_hd__decap_12
XFILLER_30_321 VPWR VGND VPWR VGND sky130_fd_sc_hd__decap_3
X_1900_ VPWR VGND _2007_/CLK _1640_/Y _2035_/A _1900_/D VPWR VGND sky130_fd_sc_hd__edfxtp_1
X_1693_ VPWR VGND VGND VPWR _1693_/A _1693_/B _1823_/D sky130_fd_sc_hd__nor2_1
X_1762_ VPWR VGND _2001_/CLK _1774_/DE _1762_/Q _1762_/D VPWR VGND sky130_fd_sc_hd__edfxtp_1
XFILLER_38_421 VGND VPWR VPWR VGND sky130_fd_sc_hd__decap_4
XFILLER_33_181 VGND VPWR VPWR VGND sky130_fd_sc_hd__decap_4
X_1058_ VGND VPWR VGND VPWR _1059_/S0 _1716_/Q _1700_/Q _1064_/S1 _1732_/Q _1748_/Q
+ _1058_/X sky130_fd_sc_hd__mux4_2
XFILLER_15_27 VPWR VGND VPWR VGND sky130_fd_sc_hd__decap_8
X_1127_ VGND VPWR VGND VPWR _1127_/S0 _1744_/Q _1712_/Q _1127_/S1 _1776_/Q _1808_/Q
+ _1127_/X sky130_fd_sc_hd__mux4_2
XFILLER_21_365 VGND VPWR VPWR VGND sky130_fd_sc_hd__decap_4
XFILLER_21_387 VGND VPWR VPWR VGND sky130_fd_sc_hd__decap_4
XPHY_EDGE_ROW_1_Right_1 VPWR VGND VPWR VGND sky130_fd_sc_hd__decap_3
XFILLER_71_210 VGND VPWR VPWR VGND sky130_fd_sc_hd__decap_4
XFILLER_56_12 VPWR VGND VPWR VGND sky130_fd_sc_hd__decap_6
XFILLER_12_365 VGND VPWR VPWR VGND sky130_fd_sc_hd__decap_12
X_2030_ VPWR VGND _2030_/X _2030_/A VPWR VGND sky130_fd_sc_hd__buf_2
XFILLER_62_265 VGND VPWR VPWR VGND sky130_fd_sc_hd__decap_12
XFILLER_22_129 VPWR VGND VPWR VGND sky130_fd_sc_hd__decap_8
XFILLER_30_151 VGND VPWR VPWR VGND sky130_fd_sc_hd__decap_12
X_1745_ VPWR VGND _1777_/CLK _1754_/DE _1745_/Q _1745_/D VPWR VGND sky130_fd_sc_hd__edfxtp_1
X_1814_ VPWR VGND _2001_/CLK _1817_/DE _1814_/Q _1814_/D VPWR VGND sky130_fd_sc_hd__edfxtp_1
Xhold369 _1839_/D _1944_/Q VPWR VGND VGND VPWR sky130_fd_sc_hd__dlygate4sd3_1
X_1676_ VPWR VGND VGND VPWR _1691_/A _1676_/Y sky130_fd_sc_hd__inv_1
Xhold347 _1898_/D _2005_/Q VPWR VGND VGND VPWR sky130_fd_sc_hd__dlygate4sd3_1
Xhold358 _1899_/D _2006_/Q VPWR VGND VGND VPWR sky130_fd_sc_hd__dlygate4sd3_1
XFILLER_26_15 VPWR VGND VPWR VGND sky130_fd_sc_hd__decap_3
XFILLER_42_58 VGND VPWR VPWR VGND sky130_fd_sc_hd__decap_12
Xclkbuf_leaf_33_clk _1788_/CLK clkbuf_3_1__f_clk/X VPWR VGND VGND VPWR sky130_fd_sc_hd__clkbuf_8
XFILLER_21_162 VPWR VGND VPWR VGND sky130_fd_sc_hd__decap_6
XFILLER_67_77 VGND VPWR VPWR VGND sky130_fd_sc_hd__decap_4
XFILLER_17_413 VPWR VGND VPWR VGND sky130_fd_sc_hd__decap_6
XFILLER_32_91 VPWR VGND VPWR VGND sky130_fd_sc_hd__decap_8
Xclkbuf_leaf_24_clk _1777_/CLK clkbuf_3_4__f_clk/X VPWR VGND VGND VPWR sky130_fd_sc_hd__clkbuf_8
XFILLER_8_111 VGND VPWR VPWR VGND sky130_fd_sc_hd__decap_4
X_1461_ VPWR VGND VPWR VGND _2018_/A _2017_/A _2019_/A _1463_/A sky130_fd_sc_hd__a21oi_1
X_1392_ VGND VPWR VPWR VGND _1754_/D _1402_/B _1854_/Q sky130_fd_sc_hd__and2_0
X_1530_ VGND VPWR VPWR VGND _1790_/D _1629_/B _1858_/Q sky130_fd_sc_hd__and2_0
XFILLER_67_379 VPWR VGND VPWR VGND sky130_fd_sc_hd__decap_6
X_2013_ VPWR VGND _2016_/CLK _2016_/DE _2013_/Q _2013_/D VPWR VGND sky130_fd_sc_hd__edfxtp_1
Xclkbuf_leaf_15_clk _1986_/CLK clkbuf_3_6__f_clk/X VPWR VGND VGND VPWR sky130_fd_sc_hd__clkbuf_8
XFILLER_2_309 VGND VPWR VPWR VGND sky130_fd_sc_hd__decap_12
X_1728_ VPWR VGND _1749_/CLK _1737_/DE _1728_/Q _1728_/D VPWR VGND sky130_fd_sc_hd__edfxtp_1
X_1659_ VPWR VGND VGND VPWR _1694_/A _1659_/Y sky130_fd_sc_hd__inv_1
XFILLER_58_379 VPWR VGND VPWR VGND sky130_fd_sc_hd__decap_8
XFILLER_53_57 VPWR VGND VPWR VGND sky130_fd_sc_hd__decap_3
XFILLER_53_46 VPWR VGND VPWR VGND sky130_fd_sc_hd__decap_8
XFILLER_5_169 VPWR VGND VPWR VGND sky130_fd_sc_hd__decap_3
XFILLER_5_125 VGND VPWR VPWR VGND sky130_fd_sc_hd__decap_12
XFILLER_64_349 VGND VPWR VPWR VGND sky130_fd_sc_hd__decap_12
XFILLER_64_305 VPWR VGND VPWR VGND sky130_fd_sc_hd__decap_3
X_0961_ VPWR VGND VPWR VGND _1881_/Q _0997_/A _0998_/A1 _0961_/Y sky130_fd_sc_hd__a21oi_1
XFILLER_17_254 VPWR VGND VPWR VGND sky130_fd_sc_hd__decap_6
XFILLER_57_3 VPWR VGND VPWR VGND sky130_fd_sc_hd__decap_3
X_0892_ VPWR VGND VGND VPWR _0986_/A _0892_/C _1875_/Q _0892_/B sky130_fd_sc_hd__maj3_1
X_1513_ VPWR VGND VGND VPWR _1941_/Q _1514_/B _2022_/A _1565_/A sky130_fd_sc_hd__mux2i_1
Xclkbuf_leaf_4_clk clkload9/A clkbuf_leaf_4_clk/A VPWR VGND VGND VPWR sky130_fd_sc_hd__clkbuf_8
X_1444_ VGND VPWR VPWR VGND _1699_/D _1448_/B _1847_/Q sky130_fd_sc_hd__and2_0
X_1375_ VGND VPWR VPWR VGND _1772_/D _1529_/B _1856_/Q sky130_fd_sc_hd__and2_0
XFILLER_58_165 VPWR VGND VPWR VGND sky130_fd_sc_hd__decap_6
XFILLER_61_319 VPWR VGND VPWR VGND sky130_fd_sc_hd__decap_3
Xfanout94 VGND VPWR _1673_/A _1264_/B VPWR VGND sky130_fd_sc_hd__clkdlybuf4s15_1
XFILLER_6_401 VGND VPWR VPWR VGND sky130_fd_sc_hd__decap_12
XFILLER_49_121 VPWR VGND VPWR VGND sky130_fd_sc_hd__decap_8
XFILLER_43_9 VPWR VGND VPWR VGND sky130_fd_sc_hd__decap_8
XFILLER_1_161 VPWR VGND VPWR VGND sky130_fd_sc_hd__decap_6
XFILLER_64_135 VGND VPWR VPWR VGND sky130_fd_sc_hd__decap_4
X_1160_ VPWR VGND VPWR VGND _1952_/Q _1940_/Q _1204_/A _1198_/A sky130_fd_sc_hd__a21oi_1
Xclkbuf_3_7__f_clk VGND VPWR VGND VPWR clkbuf_0_clk/X clkload0/A sky130_fd_sc_hd__clkbuf_16
XFILLER_49_176 VGND VPWR VPWR VGND sky130_fd_sc_hd__decap_12
XFILLER_37_349 VGND VPWR VPWR VGND sky130_fd_sc_hd__decap_12
X_1091_ VGND VPWR VGND VPWR _1261_/S1 _1756_/Q _1724_/Q _1261_/S0 _1788_/Q _1820_/Q
+ _1091_/X sky130_fd_sc_hd__mux4_2
X_0944_ VGND VPWR VPWR VGND _0944_/X _1884_/Q _1997_/Q sky130_fd_sc_hd__and2_0
XFILLER_45_393 VPWR VGND VPWR VGND sky130_fd_sc_hd__decap_8
X_1993_ VPWR VGND _1993_/CLK _1694_/Y _1993_/Q _1993_/D VPWR VGND sky130_fd_sc_hd__edfxtp_1
Xclkload20 VGND VPWR VPWR VGND _1969_/CLK clkload20/Y sky130_fd_sc_hd__clkinv_4
X_0875_ VPWR VGND VGND VPWR _0875_/A _1930_/Q _0876_/B _0875_/C sky130_fd_sc_hd__nand3_1
X_1358_ VPWR VGND VGND VPWR _1358_/Y _1358_/C _1961_/Q _1358_/D _1960_/Q sky130_fd_sc_hd__nand4b_1
X_1427_ VGND VPWR VPWR VGND _1717_/D _1433_/B _1849_/Q sky130_fd_sc_hd__and2_0
X_1289_ VGND VPWR _1916_/Q _1289_/Y _1958_/Q VPWR VGND sky130_fd_sc_hd__xnor2_1
XFILLER_34_37 VGND VPWR VPWR VGND sky130_fd_sc_hd__decap_12
XFILLER_11_205 VPWR VGND VPWR VGND sky130_fd_sc_hd__decap_6
XFILLER_11_216 VPWR VGND VPWR VGND sky130_fd_sc_hd__decap_8
Xclkload3 VGND VPWR VPWR VGND clkload3/A clkload3/Y sky130_fd_sc_hd__clkinv_2
XFILLER_19_349 VGND VPWR VPWR VGND sky130_fd_sc_hd__decap_12
XFILLER_27_393 VGND VPWR VPWR VGND sky130_fd_sc_hd__decap_12
XFILLER_10_293 VGND VPWR VPWR VGND sky130_fd_sc_hd__decap_12
X_1212_ VGND VPWR VGND VPWR _1211_/Y _1218_/A _1862_/D _1210_/Y sky130_fd_sc_hd__o21ai_0
XFILLER_37_113 VGND VPWR VPWR VGND sky130_fd_sc_hd__decap_12
X_1143_ VPWR VGND VGND VPWR _1943_/Q _1307_/A _1143_/Y sky130_fd_sc_hd__nor2_1
XFILLER_52_149 VPWR VGND VPWR VGND sky130_fd_sc_hd__decap_8
X_1074_ VPWR VGND VGND VPWR _1073_/X _1074_/Y _1072_/X _1084_/S sky130_fd_sc_hd__mux2i_1
X_1976_ _2028_/A _1994_/CLK _1976_/D VPWR VGND VPWR VGND sky130_fd_sc_hd__dfxtp_1
X_0927_ VPWR VGND VGND VPWR _0844_/Y _0925_/Y _0926_/Y _1367_/A1 _1990_/D sky130_fd_sc_hd__o22ai_1
X_0858_ VPWR VGND VGND VPWR _1927_/Q _0859_/D _0868_/B sky130_fd_sc_hd__nor2_1
XFILLER_28_168 VPWR VGND VPWR VGND sky130_fd_sc_hd__decap_8
XFILLER_28_124 VPWR VGND VPWR VGND sky130_fd_sc_hd__decap_8
X_1830_ VPWR VGND _1977_/CLK _1646_/Y _1830_/Q _1830_/D VPWR VGND sky130_fd_sc_hd__edfxtp_1
X_1761_ VPWR VGND _2006_/CLK _1770_/DE _1761_/Q _1761_/D VPWR VGND sky130_fd_sc_hd__edfxtp_1
X_1692_ VPWR VGND VGND VPWR _1693_/A _1692_/B _1824_/D sky130_fd_sc_hd__nor2_1
XPHY_EDGE_ROW_69_Left_141 VPWR VGND VPWR VGND sky130_fd_sc_hd__decap_3
XFILLER_65_274 VPWR VGND VPWR VGND sky130_fd_sc_hd__decap_6
XFILLER_65_241 VPWR VGND VPWR VGND sky130_fd_sc_hd__decap_3
XFILLER_38_400 VGND VPWR VPWR VGND sky130_fd_sc_hd__decap_12
X_1126_ VGND VPWR VGND VPWR _1127_/S0 _1728_/Q _1696_/Q _1127_/S1 _1760_/Q _1792_/Q
+ _1126_/X sky130_fd_sc_hd__mux4_2
X_1057_ VPWR VGND VGND VPWR _1953_/Q _1057_/Y _1085_/B sky130_fd_sc_hd__nand2_1
X_1959_ _1959_/Q clkload7/A _1959_/D VPWR VGND VPWR VGND sky130_fd_sc_hd__dfxtp_1
XFILLER_48_219 VGND VPWR VPWR VGND sky130_fd_sc_hd__decap_12
XFILLER_56_68 VGND VPWR VPWR VGND sky130_fd_sc_hd__decap_12
XFILLER_44_403 VPWR VGND VPWR VGND sky130_fd_sc_hd__decap_3
XFILLER_16_149 VPWR VGND VPWR VGND sky130_fd_sc_hd__decap_3
XFILLER_12_344 VGND VPWR VPWR VGND sky130_fd_sc_hd__decap_12
XFILLER_12_377 VGND VPWR VPWR VGND sky130_fd_sc_hd__decap_12
XFILLER_24_182 VGND VPWR VPWR VGND sky130_fd_sc_hd__decap_12
Xclkbuf_0_clk VGND VPWR VGND VPWR clk clkbuf_0_clk/X sky130_fd_sc_hd__clkbuf_16
X_1813_ VPWR VGND _2006_/CLK _1817_/DE _1813_/Q _1813_/D VPWR VGND sky130_fd_sc_hd__edfxtp_1
XFILLER_30_163 VPWR VGND VPWR VGND sky130_fd_sc_hd__decap_8
XFILLER_7_51 VGND VPWR VPWR VGND sky130_fd_sc_hd__decap_4
X_1744_ VPWR VGND _1807_/CLK _1754_/DE _1744_/Q _1744_/D VPWR VGND sky130_fd_sc_hd__edfxtp_1
X_1675_ VPWR VGND VGND VPWR _1694_/A _1675_/Y sky130_fd_sc_hd__inv_1
Xhold359 _1902_/D _2009_/Q VPWR VGND VGND VPWR sky130_fd_sc_hd__dlygate4sd3_1
Xhold348 _1894_/D _2001_/Q VPWR VGND VGND VPWR sky130_fd_sc_hd__dlygate4sd3_1
XPHY_EDGE_ROW_15_Right_15 VPWR VGND VPWR VGND sky130_fd_sc_hd__decap_3
XFILLER_53_255 VGND VPWR VPWR VGND sky130_fd_sc_hd__decap_12
X_1109_ VGND VPWR VGND VPWR _1130_/S0 _1750_/Q _1718_/Q _1130_/S1 _1782_/Q _1814_/Q
+ _1109_/X sky130_fd_sc_hd__mux4_2
XPHY_EDGE_ROW_24_Right_24 VPWR VGND VPWR VGND sky130_fd_sc_hd__decap_3
XPHY_EDGE_ROW_33_Right_33 VPWR VGND VPWR VGND sky130_fd_sc_hd__decap_3
XPHY_EDGE_ROW_42_Right_42 VPWR VGND VPWR VGND sky130_fd_sc_hd__decap_3
XPHY_EDGE_ROW_51_Right_51 VPWR VGND VPWR VGND sky130_fd_sc_hd__decap_3
XFILLER_12_141 VPWR VGND VPWR VGND sky130_fd_sc_hd__decap_8
X_1460_ VPWR VGND VGND VPWR _1460_/A _1460_/Y _1460_/B sky130_fd_sc_hd__nand2_1
X_1391_ VGND VPWR VPWR VGND _1755_/D _1528_/B _1855_/Q sky130_fd_sc_hd__and2_0
XPHY_EDGE_ROW_60_Right_60 VPWR VGND VPWR VGND sky130_fd_sc_hd__decap_3
X_2012_ VPWR VGND _2015_/CLK _2015_/DE _2012_/Q _2012_/D VPWR VGND sky130_fd_sc_hd__edfxtp_1
XFILLER_50_225 VPWR VGND VPWR VGND sky130_fd_sc_hd__decap_6
XFILLER_35_299 VPWR VGND VPWR VGND sky130_fd_sc_hd__decap_6
X_1658_ VPWR VGND VGND VPWR _1658_/A _1658_/Y sky130_fd_sc_hd__inv_1
XFILLER_12_29 VGND VPWR VPWR VGND sky130_fd_sc_hd__decap_4
X_1727_ VPWR VGND clkload4/A _1737_/DE _1727_/Q _1727_/D VPWR VGND sky130_fd_sc_hd__edfxtp_1
XFILLER_58_347 VGND VPWR VPWR VGND sky130_fd_sc_hd__decap_4
XFILLER_58_314 VGND VPWR VPWR VGND sky130_fd_sc_hd__decap_4
X_1589_ VGND VPWR VPWR VGND _1816_/D _1598_/B _1852_/Q sky130_fd_sc_hd__and2_0
XFILLER_66_380 VGND VPWR VPWR VGND sky130_fd_sc_hd__decap_4
XFILLER_26_244 VPWR VGND VPWR VGND sky130_fd_sc_hd__decap_8
XFILLER_64_317 VPWR VGND VPWR VGND sky130_fd_sc_hd__decap_8
XFILLER_17_233 VPWR VGND VPWR VGND sky130_fd_sc_hd__decap_3
X_0960_ VGND VPWR _0960_/B _0960_/Y _0960_/A VPWR VGND sky130_fd_sc_hd__xnor2_1
XFILLER_32_214 VPWR VGND VPWR VGND sky130_fd_sc_hd__decap_6
X_1512_ VPWR VGND VGND VPWR _1688_/A _1512_/B _1942_/D sky130_fd_sc_hd__nor2_1
X_0891_ VPWR VGND VGND VPWR _0991_/A _0991_/B _0992_/B sky130_fd_sc_hd__nor2_1
X_1443_ VGND VPWR VPWR VGND _1700_/D _1448_/B _1848_/Q sky130_fd_sc_hd__and2_0
XFILLER_4_85 VGND VPWR VPWR VGND sky130_fd_sc_hd__decap_12
XFILLER_4_41 VGND VPWR VPWR VGND sky130_fd_sc_hd__decap_12
X_1374_ VGND VPWR VPWR VGND _1773_/D _1529_/B _1857_/Q sky130_fd_sc_hd__and2_0
XFILLER_23_225 VGND VPWR VPWR VGND sky130_fd_sc_hd__decap_12
XFILLER_46_339 VGND VPWR VPWR VGND sky130_fd_sc_hd__decap_12
Xfanout95 VPWR VGND _1679_/A _1264_/B VPWR VGND sky130_fd_sc_hd__buf_2
XFILLER_6_413 VPWR VGND VPWR VGND sky130_fd_sc_hd__decap_6
XFILLER_13_94 VPWR VGND VPWR VGND sky130_fd_sc_hd__decap_6
XFILLER_36_9 VPWR VGND VPWR VGND sky130_fd_sc_hd__decap_8
XFILLER_52_309 VGND VPWR VPWR VGND sky130_fd_sc_hd__decap_12
XPHY_EDGE_ROW_32_Left_104 VPWR VGND VPWR VGND sky130_fd_sc_hd__decap_3
X_1090_ VGND VPWR VGND VPWR _1261_/S1 _1740_/Q _1708_/Q _1261_/S0 _1772_/Q _1804_/Q
+ _1090_/X sky130_fd_sc_hd__mux4_2
X_0943_ VGND VPWR _0943_/B _0943_/Y _0943_/A VPWR VGND sky130_fd_sc_hd__xnor2_1
X_0874_ VPWR VGND VPWR VGND _0875_/C _0875_/A _1930_/Q _0874_/Y sky130_fd_sc_hd__a21oi_1
X_1992_ VPWR VGND _1997_/CLK _1674_/Y _1992_/Q _1992_/D VPWR VGND sky130_fd_sc_hd__edfxtp_1
Xclkload10 VGND VPWR VPWR VGND _1995_/CLK clkload10/Y sky130_fd_sc_hd__clkinv_2
XPHY_EDGE_ROW_41_Left_113 VPWR VGND VPWR VGND sky130_fd_sc_hd__decap_3
Xclkload21 VPWR VGND VGND VPWR _1967_/CLK clkload21/Y sky130_fd_sc_hd__clkinv_1
XFILLER_55_147 VGND VPWR VPWR VGND sky130_fd_sc_hd__decap_12
X_1357_ VPWR VGND VGND VPWR _1357_/A _1357_/B _1357_/Y _1357_/C sky130_fd_sc_hd__nand3_1
XPHY_EDGE_ROW_50_Left_122 VPWR VGND VPWR VGND sky130_fd_sc_hd__decap_3
X_1288_ VGND VPWR VGND VPWR _1288_/B1 _1288_/A1 _1934_/D _1287_/Y sky130_fd_sc_hd__o21ai_0
X_1426_ VGND VPWR VPWR VGND _1718_/D _1433_/B _1850_/Q sky130_fd_sc_hd__and2_0
XFILLER_55_169 VPWR VGND VPWR VGND sky130_fd_sc_hd__decap_3
Xclkload4 VGND VPWR VPWR VGND clkload4/A clkload4/Y sky130_fd_sc_hd__clkinv_2
XFILLER_3_405 VGND VPWR VPWR VGND sky130_fd_sc_hd__decap_12
XFILLER_59_57 VGND VPWR VPWR VGND sky130_fd_sc_hd__decap_12
XFILLER_34_309 VGND VPWR VPWR VGND sky130_fd_sc_hd__decap_12
XFILLER_24_60 VGND VPWR VPWR VGND sky130_fd_sc_hd__decap_12
XFILLER_6_221 VPWR VGND VPWR VGND sky130_fd_sc_hd__decap_3
X_1142_ VPWR VGND VGND VPWR _1943_/Q _1142_/Y _1307_/A sky130_fd_sc_hd__nand2_1
X_1211_ VPWR VGND VPWR VGND _1209_/B _1218_/A _1211_/Y _1877_/D _1221_/B sky130_fd_sc_hd__a22oi_1
XFILLER_49_90 VPWR VGND VPWR VGND sky130_fd_sc_hd__decap_3
XFILLER_37_169 VGND VPWR VPWR VGND sky130_fd_sc_hd__decap_4
XFILLER_33_375 VPWR VGND VPWR VGND sky130_fd_sc_hd__decap_6
X_1073_ VGND VPWR VGND VPWR _1073_/S0 _1777_/Q _1761_/Q _1824_/Q _1793_/Q _1809_/Q
+ _1073_/X sky130_fd_sc_hd__mux4_2
X_1975_ _2027_/A _1994_/CLK _1975_/D VPWR VGND VPWR VGND sky130_fd_sc_hd__dfxtp_1
X_0857_ VPWR VGND VGND VPWR _0857_/A _0859_/D _0866_/B sky130_fd_sc_hd__nand2_1
X_0926_ VGND VPWR _0926_/B _0926_/Y _0926_/A VPWR VGND sky130_fd_sc_hd__xnor2_1
X_1409_ VGND VPWR VPWR VGND _1736_/D _1418_/B _1852_/Q sky130_fd_sc_hd__and2_0
XFILLER_45_15 VPWR VGND VPWR VGND sky130_fd_sc_hd__decap_8
XFILLER_61_69 VGND VPWR VPWR VGND sky130_fd_sc_hd__decap_4
XFILLER_61_36 VGND VPWR VPWR VGND sky130_fd_sc_hd__decap_12
XPHY_EDGE_ROW_7_Left_79 VPWR VGND VPWR VGND sky130_fd_sc_hd__decap_3
XFILLER_47_412 VGND VPWR VPWR VGND sky130_fd_sc_hd__decap_12
XFILLER_34_128 VGND VPWR VPWR VGND sky130_fd_sc_hd__decap_12
XFILLER_34_117 VPWR VGND VPWR VGND sky130_fd_sc_hd__decap_6
XFILLER_51_91 VPWR VGND VPWR VGND sky130_fd_sc_hd__decap_8
X_1691_ VPWR VGND VGND VPWR _1691_/A _1691_/B _1826_/D sky130_fd_sc_hd__nor2_1
X_1760_ VPWR VGND _2001_/CLK _1774_/DE _1760_/Q _1760_/D VPWR VGND sky130_fd_sc_hd__edfxtp_1
XFILLER_32_3 VGND VPWR VPWR VGND sky130_fd_sc_hd__decap_12
XFILLER_38_412 VPWR VGND VPWR VGND sky130_fd_sc_hd__decap_8
X_1125_ VGND VPWR VPWR VGND _1876_/D _1123_/X _1131_/S _1124_/X sky130_fd_sc_hd__mux2_1
X_1056_ VGND VPWR VGND VPWR _1052_/Y _1086_/A1 _1925_/D _1055_/Y sky130_fd_sc_hd__o21ai_0
X_0909_ VGND VPWR VPWR VGND _1884_/Q _0943_/B _0910_/B sky130_fd_sc_hd__xor2_1
X_1958_ _1958_/Q _1963_/CLK _1958_/D VPWR VGND VPWR VGND sky130_fd_sc_hd__dfxtp_2
X_1889_ VPWR VGND clkload9/A _2015_/DE _1889_/Q _1889_/D VPWR VGND sky130_fd_sc_hd__edfxtp_1
XFILLER_56_253 VGND VPWR VPWR VGND sky130_fd_sc_hd__decap_12
XFILLER_56_58 VPWR VGND VPWR VGND sky130_fd_sc_hd__decap_3
XFILLER_12_356 VPWR VGND VPWR VGND sky130_fd_sc_hd__decap_8
XFILLER_12_389 VGND VPWR VPWR VGND sky130_fd_sc_hd__decap_12
XFILLER_15_150 VGND VPWR VPWR VGND sky130_fd_sc_hd__decap_12
Xhold349 _1918_/D _1910_/Q VPWR VGND VGND VPWR sky130_fd_sc_hd__dlygate4sd3_1
X_1674_ VPWR VGND VGND VPWR _1694_/A _1674_/Y sky130_fd_sc_hd__inv_1
XFILLER_30_197 VGND VPWR VPWR VGND sky130_fd_sc_hd__decap_12
X_1812_ VPWR VGND clkload4/A _1817_/DE _1812_/Q _1812_/D VPWR VGND sky130_fd_sc_hd__edfxtp_1
XFILLER_7_393 VGND VPWR VPWR VGND sky130_fd_sc_hd__decap_12
X_1743_ VPWR VGND _1749_/CLK _1758_/DE _1743_/Q _1743_/D VPWR VGND sky130_fd_sc_hd__edfxtp_1
XFILLER_53_289 VPWR VGND VPWR VGND sky130_fd_sc_hd__decap_3
XFILLER_53_267 VGND VPWR VPWR VGND sky130_fd_sc_hd__decap_12
XFILLER_38_286 VGND VPWR VPWR VGND sky130_fd_sc_hd__decap_12
XFILLER_38_253 VPWR VGND VPWR VGND sky130_fd_sc_hd__decap_8
X_1039_ VGND VPWR VGND VPWR _1083_/S0 _1784_/Q _1768_/Q _1083_/S1 _1800_/Q _1816_/Q
+ _1039_/X sky130_fd_sc_hd__mux4_2
X_1108_ VGND VPWR VGND VPWR _1130_/S0 _1734_/Q _1702_/Q _1130_/S1 _1766_/Q _1798_/Q
+ _1108_/X sky130_fd_sc_hd__mux4_2
XFILLER_42_16 VPWR VGND VPWR VGND sky130_fd_sc_hd__decap_3
XFILLER_67_57 VGND VPWR VPWR VGND sky130_fd_sc_hd__decap_12
XFILLER_29_264 VGND VPWR VPWR VGND sky130_fd_sc_hd__decap_12
XFILLER_66_9 VGND VPWR VPWR VGND sky130_fd_sc_hd__decap_12
XFILLER_12_197 VGND VPWR VPWR VGND sky130_fd_sc_hd__decap_12
X_1390_ VGND VPWR VPWR VGND _1756_/D _1528_/B _1856_/Q sky130_fd_sc_hd__and2_0
X_2011_ VPWR VGND clkload6/A _2016_/DE _2011_/Q _2011_/D VPWR VGND sky130_fd_sc_hd__edfxtp_1
X_1657_ VPWR VGND VGND VPWR _1694_/A _1657_/Y sky130_fd_sc_hd__inv_1
X_1726_ VPWR VGND clkload3/A _1726_/DE _1726_/Q _1726_/D VPWR VGND sky130_fd_sc_hd__edfxtp_1
X_1588_ VGND VPWR VPWR VGND _1817_/D _1593_/B _1853_/Q sky130_fd_sc_hd__and2_0
XFILLER_41_237 VGND VPWR VPWR VGND sky130_fd_sc_hd__decap_4
XFILLER_17_212 VGND VPWR VPWR VGND sky130_fd_sc_hd__decap_12
X_0890_ VGND VPWR _0892_/B _0991_/B _1875_/Q VPWR VGND sky130_fd_sc_hd__xnor2_1
XFILLER_43_70 VGND VPWR VPWR VGND sky130_fd_sc_hd__decap_12
X_1511_ VPWR VGND VGND VPWR _1837_/D _1512_/B _2023_/A _1565_/A sky130_fd_sc_hd__mux2i_1
X_1442_ VGND VPWR VPWR VGND _1701_/D _1448_/B _1849_/Q sky130_fd_sc_hd__and2_0
XFILLER_67_178 VPWR VGND VPWR VGND sky130_fd_sc_hd__decap_3
XFILLER_4_97 VGND VPWR VPWR VGND sky130_fd_sc_hd__decap_12
XFILLER_4_53 VGND VPWR VPWR VGND sky130_fd_sc_hd__decap_12
X_1373_ VGND VPWR VPWR VGND _1775_/D _1629_/B _1843_/Q sky130_fd_sc_hd__and2_0
XFILLER_63_373 VGND VPWR VPWR VGND sky130_fd_sc_hd__decap_12
XFILLER_23_204 VGND VPWR VPWR VGND sky130_fd_sc_hd__decap_12
XFILLER_23_237 VPWR VGND VPWR VGND sky130_fd_sc_hd__decap_8
X_1709_ VPWR VGND _2009_/CLK _1710_/DE _1709_/Q _1709_/D VPWR VGND sky130_fd_sc_hd__edfxtp_1
XFILLER_54_373 VGND VPWR VPWR VGND sky130_fd_sc_hd__decap_12
XFILLER_46_329 VPWR VGND VPWR VGND sky130_fd_sc_hd__decap_3
Xfanout96 VGND VPWR _1680_/A _1264_/B VPWR VGND sky130_fd_sc_hd__clkdlybuf4s15_1
XFILLER_10_421 VGND VPWR VPWR VGND sky130_fd_sc_hd__decap_4
XFILLER_13_51 VGND VPWR VPWR VGND sky130_fd_sc_hd__decap_4
XFILLER_14_248 VGND VPWR VPWR VGND sky130_fd_sc_hd__decap_4
XFILLER_13_62 VPWR VGND VPWR VGND sky130_fd_sc_hd__decap_8
XFILLER_38_70 VGND VPWR VPWR VGND sky130_fd_sc_hd__decap_12
XFILLER_29_9 VGND VPWR VPWR VGND sky130_fd_sc_hd__decap_4
XFILLER_62_3 VGND VPWR VPWR VGND sky130_fd_sc_hd__decap_12
Xclkload22 VPWR VGND VGND VPWR _1982_/CLK clkload22/Y sky130_fd_sc_hd__clkinv_1
X_0942_ VGND VPWR VGND VPWR _0941_/Y _1367_/A1 _1989_/D _0928_/Y sky130_fd_sc_hd__o21ai_0
X_0873_ VGND VPWR _0873_/B _0914_/B _1931_/Q VPWR VGND sky130_fd_sc_hd__xnor2_1
X_1991_ VPWR VGND _1997_/CLK _1675_/Y _1991_/Q _1991_/D VPWR VGND sky130_fd_sc_hd__edfxtp_1
Xclkload11 VGND VPWR _1925_/CLK clkload11/X VPWR VGND sky130_fd_sc_hd__clkbuf_4
XFILLER_13_281 VPWR VGND VPWR VGND sky130_fd_sc_hd__decap_8
XFILLER_68_421 VGND VPWR VPWR VGND sky130_fd_sc_hd__decap_4
X_1425_ VGND VPWR VPWR VGND _1719_/D _1526_/B _1851_/Q sky130_fd_sc_hd__and2_0
XFILLER_55_159 VPWR VGND VPWR VGND sky130_fd_sc_hd__decap_8
X_1356_ VPWR VGND VGND VPWR _1356_/A _1997_/D _1356_/B sky130_fd_sc_hd__nand2_1
XFILLER_18_29 VGND VPWR VPWR VGND sky130_fd_sc_hd__decap_4
X_1287_ VPWR VGND VGND VPWR _1286_/X _1287_/Y _1285_/X _1287_/S sky130_fd_sc_hd__mux2i_1
Xclkload5 VGND VPWR VPWR VGND clkload5/A clkload5/Y sky130_fd_sc_hd__clkinv_2
XFILLER_3_417 VPWR VGND VPWR VGND sky130_fd_sc_hd__decap_8
XFILLER_59_47 VGND VPWR VPWR VGND sky130_fd_sc_hd__decap_4
XFILLER_46_137 VPWR VGND VPWR VGND sky130_fd_sc_hd__decap_3
XFILLER_42_343 VGND VPWR VPWR VGND sky130_fd_sc_hd__decap_12
XFILLER_69_218 VPWR VGND VPWR VGND sky130_fd_sc_hd__decap_6
X_1141_ VPWR VGND VGND VPWR _1165_/A _1141_/B _1183_/A sky130_fd_sc_hd__nor2_1
X_1210_ VGND VPWR _1210_/B _1210_/Y _1210_/A VPWR VGND sky130_fd_sc_hd__xnor2_1
X_1072_ VGND VPWR VGND VPWR _1073_/S0 _1713_/Q _1697_/Q _1824_/Q _1729_/Q _1745_/Q
+ _1072_/X sky130_fd_sc_hd__mux4_2
X_1974_ _2026_/A _1988_/CLK _1974_/D VPWR VGND VPWR VGND sky130_fd_sc_hd__dfxtp_1
XFILLER_18_395 VGND VPWR VPWR VGND sky130_fd_sc_hd__decap_12
XPHY_EDGE_ROW_23_Left_95 VPWR VGND VPWR VGND sky130_fd_sc_hd__decap_3
X_0856_ VPWR VGND VGND VPWR _0856_/Y _0863_/B _1925_/Q _1924_/Q _1923_/Q sky130_fd_sc_hd__nor4_1
X_0925_ VPWR VGND VPWR VGND _1886_/Q _1997_/Q _1366_/B1 _0925_/Y sky130_fd_sc_hd__a21oi_1
X_1408_ VGND VPWR VPWR VGND _1737_/D _1418_/B _1853_/Q sky130_fd_sc_hd__and2_0
XFILLER_71_405 VGND VPWR VPWR VGND sky130_fd_sc_hd__decap_12
X_1339_ VGND VPWR VGND VPWR _1338_/Y _1339_/A1 _1998_/D _1690_/A sky130_fd_sc_hd__o21ai_0
XFILLER_61_48 VPWR VGND VPWR VGND sky130_fd_sc_hd__decap_8
XFILLER_24_365 VGND VPWR VPWR VGND sky130_fd_sc_hd__decap_4
XFILLER_3_225 VGND VPWR VPWR VGND sky130_fd_sc_hd__decap_12
XFILLER_10_41 VPWR VGND VPWR VGND sky130_fd_sc_hd__decap_3
XFILLER_10_74 VPWR VGND VPWR VGND sky130_fd_sc_hd__decap_8
XFILLER_10_85 VGND VPWR VPWR VGND sky130_fd_sc_hd__decap_12
XFILLER_59_262 VGND VPWR VPWR VGND sky130_fd_sc_hd__decap_12
XFILLER_19_61 VPWR VGND VPWR VGND sky130_fd_sc_hd__decap_3
XFILLER_27_181 VPWR VGND VPWR VGND sky130_fd_sc_hd__decap_8
XFILLER_15_365 VPWR VGND VPWR VGND sky130_fd_sc_hd__decap_3
X_1690_ VPWR VGND VGND VPWR _1690_/A _1935_/D sky130_fd_sc_hd__inv_1
XFILLER_25_3 VPWR VGND VPWR VGND sky130_fd_sc_hd__decap_8
XFILLER_65_210 VPWR VGND VPWR VGND sky130_fd_sc_hd__decap_6
XFILLER_53_416 VPWR VGND VPWR VGND sky130_fd_sc_hd__decap_8
X_1055_ VPWR VGND VGND VPWR _1054_/X _1055_/Y _1053_/X _1084_/S sky130_fd_sc_hd__mux2i_1
X_1124_ VGND VPWR VGND VPWR _1127_/S0 _1745_/Q _1713_/Q _1127_/S1 _1777_/Q _1809_/Q
+ _1124_/X sky130_fd_sc_hd__mux4_2
X_1957_ _1957_/Q _2000_/CLK _1957_/D VPWR VGND VPWR VGND sky130_fd_sc_hd__dfxtp_2
XFILLER_33_151 VGND VPWR VPWR VGND sky130_fd_sc_hd__decap_12
X_0908_ VPWR VGND VGND VPWR _0943_/A _0949_/A _1883_/Q _0908_/B sky130_fd_sc_hd__maj3_1
X_0839_ VPWR VGND VGND VPWR _1933_/Q _0839_/Y sky130_fd_sc_hd__inv_1
X_1888_ VPWR VGND _1993_/CLK _1932_/DE _1888_/Q _1888_/D VPWR VGND sky130_fd_sc_hd__edfxtp_1
Xclkbuf_leaf_36_clk _2016_/CLK clkbuf_3_1__f_clk/X VPWR VGND VGND VPWR sky130_fd_sc_hd__clkbuf_8
XFILLER_21_51 VGND VPWR VPWR VGND sky130_fd_sc_hd__decap_4
XFILLER_21_62 VGND VPWR VPWR VGND sky130_fd_sc_hd__decap_12
XFILLER_47_221 VPWR VGND VPWR VGND sky130_fd_sc_hd__decap_3
Xclkbuf_leaf_27_clk _2008_/CLK clkbuf_3_5__f_clk/X VPWR VGND VGND VPWR sky130_fd_sc_hd__clkbuf_8
X_1811_ VPWR VGND _2006_/CLK _1817_/DE _1811_/Q _1811_/D VPWR VGND sky130_fd_sc_hd__edfxtp_1
XFILLER_15_162 VPWR VGND VPWR VGND sky130_fd_sc_hd__decap_6
X_1673_ VPWR VGND VGND VPWR _1673_/A _1673_/Y sky130_fd_sc_hd__inv_1
XFILLER_7_361 VGND VPWR VPWR VGND sky130_fd_sc_hd__decap_12
X_1742_ VPWR VGND clkload3/A _1742_/DE _1742_/Q _1742_/D VPWR VGND sky130_fd_sc_hd__edfxtp_1
Xclkbuf_leaf_18_clk _1969_/CLK clkload0/A VPWR VGND VGND VPWR sky130_fd_sc_hd__clkbuf_8
XFILLER_38_298 VPWR VGND VPWR VGND sky130_fd_sc_hd__decap_8
X_1107_ VGND VPWR VPWR VGND _1882_/D _1105_/X _1826_/Q _1106_/X sky130_fd_sc_hd__mux2_1
XFILLER_26_29 VGND VPWR VPWR VGND sky130_fd_sc_hd__decap_4
XPHY_EDGE_ROW_5_Right_5 VPWR VGND VPWR VGND sky130_fd_sc_hd__decap_3
X_1038_ VGND VPWR VGND VPWR _1083_/S0 _1720_/Q _1704_/Q _1083_/S1 _1736_/Q _1752_/Q
+ _1038_/X sky130_fd_sc_hd__mux4_2
XFILLER_5_309 VGND VPWR VPWR VGND sky130_fd_sc_hd__decap_12
XPHY_EDGE_ROW_10_Left_82 VPWR VGND VPWR VGND sky130_fd_sc_hd__decap_3
XFILLER_67_69 VGND VPWR VPWR VGND sky130_fd_sc_hd__decap_4
XFILLER_29_276 VGND VPWR VPWR VGND sky130_fd_sc_hd__decap_4
X_2010_ VPWR VGND clkload6/A _2016_/DE _2010_/Q _2010_/D VPWR VGND sky130_fd_sc_hd__edfxtp_1
X_1725_ VPWR VGND _2009_/CLK _1726_/DE _1725_/Q _1725_/D VPWR VGND sky130_fd_sc_hd__edfxtp_1
Xclkbuf_leaf_7_clk clkload7/A clkbuf_leaf_9_clk/A VPWR VGND VGND VPWR sky130_fd_sc_hd__clkbuf_8
X_1587_ VGND VPWR VPWR VGND _1818_/D _1593_/B _1854_/Q sky130_fd_sc_hd__and2_0
X_1656_ VPWR VGND VGND VPWR _1658_/A _1656_/Y sky130_fd_sc_hd__inv_1
XFILLER_7_180 VGND VPWR VPWR VGND sky130_fd_sc_hd__decap_4
XFILLER_49_305 VPWR VGND VPWR VGND sky130_fd_sc_hd__decap_3
XFILLER_57_382 VPWR VGND VPWR VGND sky130_fd_sc_hd__decap_6
X_1510_ VPWR VGND VPWR VGND _1943_/D _1671_/A _1509_/Y _1543_/A _1606_/C sky130_fd_sc_hd__a211oi_1
XFILLER_4_65 VGND VPWR VPWR VGND sky130_fd_sc_hd__decap_12
X_1441_ VGND VPWR VPWR VGND _1702_/D _1448_/B _1850_/Q sky130_fd_sc_hd__and2_0
XFILLER_67_113 VGND VPWR VPWR VGND sky130_fd_sc_hd__decap_12
Xinput290 VPWR VGND _1477_/A1 mem_rdata[13] VPWR VGND sky130_fd_sc_hd__buf_4
X_1372_ VGND VPWR VPWR VGND _1776_/D _1629_/B _1844_/Q sky130_fd_sc_hd__and2_0
XFILLER_2_109 VGND VPWR VPWR VGND sky130_fd_sc_hd__decap_12
X_1708_ VPWR VGND _1788_/CLK _1708_/DE _1708_/Q _1708_/D VPWR VGND sky130_fd_sc_hd__edfxtp_1
X_1639_ VPWR VGND VGND VPWR _1645_/A _1639_/Y sky130_fd_sc_hd__inv_1
XFILLER_39_393 VGND VPWR VPWR VGND sky130_fd_sc_hd__decap_12
Xfanout97 VGND VPWR _1264_/B _1658_/A VPWR VGND sky130_fd_sc_hd__clkdlybuf4s15_1
XFILLER_38_60 VPWR VGND VPWR VGND sky130_fd_sc_hd__decap_6
XFILLER_60_344 VPWR VGND VPWR VGND sky130_fd_sc_hd__decap_3
XFILLER_60_322 VPWR VGND VPWR VGND sky130_fd_sc_hd__decap_3
XFILLER_54_81 VPWR VGND VPWR VGND sky130_fd_sc_hd__decap_3
X_0941_ VGND VPWR VPWR VGND _0929_/X _0941_/Y _1930_/Q _0974_/A _0939_/Y _0940_/Y
+ sky130_fd_sc_hd__a32oi_1
X_1990_ VPWR VGND _1997_/CLK _1676_/Y _1990_/Q _1990_/D VPWR VGND sky130_fd_sc_hd__edfxtp_1
XFILLER_55_3 VPWR VGND VPWR VGND sky130_fd_sc_hd__decap_3
X_0872_ VGND VPWR _0872_/B _0916_/B _0872_/A VPWR VGND sky130_fd_sc_hd__xnor2_1
Xclkload12 VGND VPWR _1807_/CLK clkload12/X VPWR VGND sky130_fd_sc_hd__clkbuf_4
X_1355_ VPWR VGND VGND VPWR _1355_/A _1356_/B _1357_/C sky130_fd_sc_hd__nand2_1
X_1424_ VGND VPWR VPWR VGND _1720_/D _1433_/B _1852_/Q sky130_fd_sc_hd__and2_0
XFILLER_55_116 VGND VPWR VPWR VGND sky130_fd_sc_hd__decap_4
X_1286_ VGND VPWR VGND VPWR _1286_/S0 _1790_/Q _1774_/Q _1286_/S1 _1806_/Q _1822_/Q
+ _1286_/X sky130_fd_sc_hd__mux4_2
Xplace193 VPWR VGND _1460_/B _1560_/B VPWR VGND sky130_fd_sc_hd__buf_2
XFILLER_51_388 VGND VPWR VPWR VGND sky130_fd_sc_hd__decap_4
Xclkload6 VGND VPWR VGND VPWR clkload6/A clkload6/Y sky130_fd_sc_hd__bufinv_16
XFILLER_59_15 VPWR VGND VPWR VGND sky130_fd_sc_hd__decap_6
XFILLER_46_127 VPWR VGND VPWR VGND sky130_fd_sc_hd__decap_6
XFILLER_42_355 VPWR VGND VPWR VGND sky130_fd_sc_hd__decap_8
XFILLER_27_363 VGND VPWR VPWR VGND sky130_fd_sc_hd__decap_4
XFILLER_10_285 VPWR VGND VPWR VGND sky130_fd_sc_hd__decap_3
XFILLER_41_9 VPWR VGND VPWR VGND sky130_fd_sc_hd__decap_8
XFILLER_65_414 VPWR VGND VPWR VGND sky130_fd_sc_hd__decap_3
X_1140_ VPWR VGND VGND VPWR _1944_/Q _1140_/B _1141_/B sky130_fd_sc_hd__nor2_1
X_1071_ VGND VPWR VGND VPWR _1070_/Y _1086_/A1 _1922_/D _1069_/Y sky130_fd_sc_hd__o21ai_0
X_1973_ _2025_/A _1988_/CLK _1973_/D VPWR VGND VPWR VGND sky130_fd_sc_hd__dfxtp_1
XFILLER_60_141 VPWR VGND VPWR VGND sky130_fd_sc_hd__decap_3
X_0924_ VPWR VGND VGND VPWR _0872_/A _0922_/Y _0923_/Y _1367_/A1 _1991_/D sky130_fd_sc_hd__o22ai_1
XFILLER_33_333 VPWR VGND VPWR VGND sky130_fd_sc_hd__decap_3
X_0855_ VPWR VGND VPWR VGND _1919_/Q _1922_/Q _1921_/Q _1920_/Q _0863_/B sky130_fd_sc_hd__or4_1
X_1338_ VPWR VGND VGND VPWR _1338_/A _1338_/Y _1690_/A sky130_fd_sc_hd__nand2_1
X_1407_ VGND VPWR VPWR VGND _1738_/D _1527_/B _1854_/Q sky130_fd_sc_hd__and2_0
XFILLER_29_18 VPWR VGND VPWR VGND sky130_fd_sc_hd__decap_6
XFILLER_71_417 VPWR VGND VPWR VGND sky130_fd_sc_hd__decap_3
X_1269_ VGND VPWR VGND VPWR _1613_/B _1658_/A _1269_/X sky130_fd_sc_hd__or2_0
XFILLER_24_344 VGND VPWR VPWR VGND sky130_fd_sc_hd__decap_12
XFILLER_3_237 VGND VPWR VPWR VGND sky130_fd_sc_hd__decap_12
XFILLER_59_274 VPWR VGND VPWR VGND sky130_fd_sc_hd__decap_3
XFILLER_19_51 VGND VPWR VPWR VGND sky130_fd_sc_hd__decap_4
XFILLER_42_141 VGND VPWR VPWR VGND sky130_fd_sc_hd__decap_12
XPHY_EDGE_ROW_29_Left_101 VPWR VGND VPWR VGND sky130_fd_sc_hd__decap_3
XFILLER_18_3 VGND VPWR VPWR VGND sky130_fd_sc_hd__decap_12
XPHY_EDGE_ROW_38_Left_110 VPWR VGND VPWR VGND sky130_fd_sc_hd__decap_3
X_1054_ VGND VPWR VGND VPWR _1059_/S0 _1781_/Q _1765_/Q _1064_/S1 _1797_/Q _1813_/Q
+ _1054_/X sky130_fd_sc_hd__mux4_2
X_1123_ VGND VPWR VGND VPWR _1127_/S0 _1729_/Q _1697_/Q _1127_/S1 _1761_/Q _1793_/Q
+ _1123_/X sky130_fd_sc_hd__mux4_2
X_1956_ _1956_/Q clkload7/A _1956_/D VPWR VGND VPWR VGND sky130_fd_sc_hd__dfxtp_1
X_0907_ VGND VPWR VPWR VGND _1883_/Q _0949_/B _0908_/B sky130_fd_sc_hd__xor2_1
X_1887_ VPWR VGND _1993_/CLK _1932_/DE _1887_/Q _1887_/D VPWR VGND sky130_fd_sc_hd__edfxtp_1
X_0838_ VPWR VGND VGND VPWR _0974_/A _0838_/Y sky130_fd_sc_hd__inv_1
XFILLER_44_417 VPWR VGND VPWR VGND sky130_fd_sc_hd__decap_3
XFILLER_71_225 VPWR VGND VPWR VGND sky130_fd_sc_hd__decap_8
XFILLER_21_74 VPWR VGND VPWR VGND sky130_fd_sc_hd__decap_6
XFILLER_21_85 VPWR VGND VPWR VGND sky130_fd_sc_hd__decap_6
XFILLER_21_96 VGND VPWR VPWR VGND sky130_fd_sc_hd__decap_12
XFILLER_47_255 VGND VPWR VPWR VGND sky130_fd_sc_hd__decap_12
X_1810_ VPWR VGND _2008_/CLK _1817_/DE _1810_/Q _1810_/D VPWR VGND sky130_fd_sc_hd__edfxtp_1
X_1741_ VPWR VGND _2009_/CLK _1742_/DE _1741_/Q _1741_/D VPWR VGND sky130_fd_sc_hd__edfxtp_1
X_1672_ VPWR VGND VGND VPWR _1679_/A _1672_/Y sky130_fd_sc_hd__inv_1
XFILLER_7_373 VGND VPWR VPWR VGND sky130_fd_sc_hd__decap_12
XFILLER_53_203 VGND VPWR VPWR VGND sky130_fd_sc_hd__decap_12
X_1106_ VGND VPWR VGND VPWR _1261_/S1 _1751_/Q _1719_/Q _1261_/S0 _1783_/Q _1815_/Q
+ _1106_/X sky130_fd_sc_hd__mux4_2
X_1037_ VGND VPWR VGND VPWR _1288_/B1 _1288_/A1 _1929_/D _1036_/Y sky130_fd_sc_hd__o21ai_0
X_1939_ _1939_/Q _1967_/CLK _1939_/D VPWR VGND VPWR VGND sky130_fd_sc_hd__dfxtp_1
XFILLER_67_15 VGND VPWR VPWR VGND sky130_fd_sc_hd__decap_12
XFILLER_29_255 VGND VPWR VPWR VGND sky130_fd_sc_hd__decap_4
XPHY_EDGE_ROW_11_Right_11 VPWR VGND VPWR VGND sky130_fd_sc_hd__decap_3
XFILLER_12_133 VPWR VGND VPWR VGND sky130_fd_sc_hd__decap_3
XFILLER_12_155 VPWR VGND VPWR VGND sky130_fd_sc_hd__decap_8
XFILLER_16_85 VPWR VGND VPWR VGND sky130_fd_sc_hd__decap_8
XFILLER_4_365 VGND VPWR VPWR VGND sky130_fd_sc_hd__decap_12
XFILLER_4_321 VGND VPWR VPWR VGND sky130_fd_sc_hd__decap_12
XPHY_EDGE_ROW_20_Right_20 VPWR VGND VPWR VGND sky130_fd_sc_hd__decap_3
XFILLER_35_225 VGND VPWR VPWR VGND sky130_fd_sc_hd__decap_12
X_1724_ VPWR VGND _1788_/CLK _1724_/DE _1724_/Q _1724_/D VPWR VGND sky130_fd_sc_hd__edfxtp_1
X_1655_ VPWR VGND VGND VPWR _1679_/A _1655_/Y sky130_fd_sc_hd__inv_1
X_1586_ VGND VPWR VPWR VGND _1819_/D _1593_/B _1855_/Q sky130_fd_sc_hd__and2_0
XFILLER_66_350 VGND VPWR VPWR VGND sky130_fd_sc_hd__decap_12
XFILLER_34_291 VGND VPWR VPWR VGND sky130_fd_sc_hd__decap_12
XFILLER_5_107 VGND VPWR VPWR VGND sky130_fd_sc_hd__decap_4
XFILLER_17_225 VPWR VGND VPWR VGND sky130_fd_sc_hd__decap_8
XFILLER_25_291 VGND VPWR VPWR VGND sky130_fd_sc_hd__decap_12
X_1371_ VGND VPWR VPWR VGND _1777_/D _1630_/B _1845_/Q sky130_fd_sc_hd__and2_0
XFILLER_4_77 VPWR VGND VPWR VGND sky130_fd_sc_hd__decap_6
X_1440_ VGND VPWR VPWR VGND _1703_/D _1525_/B _1851_/Q sky130_fd_sc_hd__and2_0
XFILLER_67_169 VPWR VGND VPWR VGND sky130_fd_sc_hd__decap_6
Xinput291 VPWR VGND _1473_/A1 mem_rdata[14] VPWR VGND sky130_fd_sc_hd__buf_4
Xclkbuf_3_2__f_clk VGND VPWR VGND VPWR clkbuf_0_clk/X clkbuf_leaf_9_clk/A sky130_fd_sc_hd__clkbuf_16
X_1707_ VPWR VGND _2009_/CLK _1710_/DE _1707_/Q _1707_/D VPWR VGND sky130_fd_sc_hd__edfxtp_1
X_1638_ VPWR VGND VGND VPWR _1658_/A _1638_/Y sky130_fd_sc_hd__inv_1
X_1569_ VPWR VGND VGND VPWR _1573_/A _1569_/Y _1569_/B sky130_fd_sc_hd__nand2_1
XFILLER_58_136 VGND VPWR VPWR VGND sky130_fd_sc_hd__decap_4
XFILLER_58_114 VPWR VGND VPWR VGND sky130_fd_sc_hd__decap_6
XFILLER_46_309 VGND VPWR VPWR VGND sky130_fd_sc_hd__decap_4
XFILLER_39_372 VGND VPWR VPWR VGND sky130_fd_sc_hd__decap_12
XFILLER_10_401 VGND VPWR VPWR VGND sky130_fd_sc_hd__decap_12
Xfanout98 VPWR VGND _1658_/A _1647_/A VPWR VGND sky130_fd_sc_hd__buf_2
XFILLER_57_180 VPWR VGND VPWR VGND sky130_fd_sc_hd__decap_8
X_0940_ VPWR VGND VGND VPWR _1842_/Q _0947_/B _0940_/Y sky130_fd_sc_hd__nand2b_1
X_0871_ VPWR VGND VPWR VGND _1931_/Q _0875_/A _0873_/B _0872_/B sky130_fd_sc_hd__a21oi_1
Xclkload13 VGND VPWR _1954_/CLK clkload13/X VPWR VGND sky130_fd_sc_hd__clkbuf_4
X_1354_ VPWR VGND VPWR VGND _1353_/D _1997_/Q _1353_/Y _1356_/A sky130_fd_sc_hd__a21oi_1
XFILLER_28_309 VGND VPWR VPWR VGND sky130_fd_sc_hd__decap_12
X_1423_ VGND VPWR VPWR VGND _1721_/D _1526_/B _1853_/Q sky130_fd_sc_hd__and2_0
X_1285_ VGND VPWR VGND VPWR _1286_/S0 _1726_/Q _1710_/Q _1286_/S1 _1742_/Q _1758_/Q
+ _1285_/X sky130_fd_sc_hd__mux4_2
XFILLER_70_109 VGND VPWR VPWR VGND sky130_fd_sc_hd__decap_12
Xplace194 VPWR VGND _1584_/S _1449_/Y VPWR VGND sky130_fd_sc_hd__buf_2
Xclkload7 VGND VPWR VGND VPWR clkload7/A clkload7/Y sky130_fd_sc_hd__bufinv_16
XFILLER_59_401 VPWR VGND VPWR VGND sky130_fd_sc_hd__decap_3
XFILLER_54_183 VGND VPWR VPWR VGND sky130_fd_sc_hd__decap_12
XFILLER_24_85 VGND VPWR VPWR VGND sky130_fd_sc_hd__decap_4
X_1070_ VPWR VGND VGND VPWR _1209_/B _1070_/Y _1085_/B sky130_fd_sc_hd__nand2_1
X_1972_ _2024_/A _1986_/CLK _1972_/D VPWR VGND VPWR VGND sky130_fd_sc_hd__dfxtp_1
XFILLER_60_164 VPWR VGND VPWR VGND sky130_fd_sc_hd__decap_6
X_0923_ VGND VPWR _0923_/B _0923_/Y _0923_/A VPWR VGND sky130_fd_sc_hd__xnor2_1
X_0854_ VPWR VGND VPWR VGND _1888_/Q _1997_/Q _1366_/B1 _0854_/Y sky130_fd_sc_hd__a21oi_1
XFILLER_33_389 VPWR VGND VPWR VGND sky130_fd_sc_hd__decap_3
XPHY_EDGE_ROW_49_Right_49 VPWR VGND VPWR VGND sky130_fd_sc_hd__decap_3
XFILLER_68_253 VPWR VGND VPWR VGND sky130_fd_sc_hd__decap_8
XPHY_EDGE_ROW_58_Right_58 VPWR VGND VPWR VGND sky130_fd_sc_hd__decap_3
X_1337_ VPWR VGND VGND VPWR _1353_/D _1996_/D _1336_/Y _1333_/Y _1332_/Y sky130_fd_sc_hd__o211ai_1
X_1268_ VPWR VGND VGND VPWR _1283_/A _1891_/Q _1892_/Q _1268_/Y sky130_fd_sc_hd__nor3_1
X_1406_ VGND VPWR VPWR VGND _1739_/D _1527_/B _1855_/Q sky130_fd_sc_hd__and2_0
X_1199_ VPWR VGND VGND VPWR _1218_/A _1199_/B _1199_/Y sky130_fd_sc_hd__nor2_1
XFILLER_51_197 VPWR VGND VPWR VGND sky130_fd_sc_hd__decap_8
XFILLER_24_356 VPWR VGND VPWR VGND sky130_fd_sc_hd__decap_3
XPHY_EDGE_ROW_67_Right_67 VPWR VGND VPWR VGND sky130_fd_sc_hd__decap_3
XFILLER_3_205 VGND VPWR VPWR VGND sky130_fd_sc_hd__decap_12
XFILLER_3_249 VGND VPWR VPWR VGND sky130_fd_sc_hd__decap_12
XFILLER_42_197 VPWR VGND VPWR VGND sky130_fd_sc_hd__decap_6
XFILLER_42_153 VGND VPWR VPWR VGND sky130_fd_sc_hd__decap_4
XFILLER_35_95 VGND VPWR VPWR VGND sky130_fd_sc_hd__decap_12
XFILLER_30_348 VGND VPWR VPWR VGND sky130_fd_sc_hd__decap_12
X_1122_ VGND VPWR VPWR VGND _1877_/D _1120_/X _1131_/S _1121_/X sky130_fd_sc_hd__mux2_1
X_1053_ VGND VPWR VGND VPWR _1059_/S0 _1717_/Q _1701_/Q _1064_/S1 _1733_/Q _1749_/Q
+ _1053_/X sky130_fd_sc_hd__mux4_2
XFILLER_21_337 VPWR VGND VPWR VGND sky130_fd_sc_hd__decap_8
X_0906_ VPWR VGND VGND VPWR _0949_/A _0954_/A _1882_/Q _0906_/B sky130_fd_sc_hd__maj3_1
X_0837_ VPWR VGND VGND VPWR _1995_/Q _0875_/A sky130_fd_sc_hd__inv_1
X_1955_ _1955_/Q _1979_/CLK _1955_/D VPWR VGND VPWR VGND sky130_fd_sc_hd__dfxtp_1
X_1886_ VPWR VGND clkload9/A _2015_/DE _1886_/Q _1886_/D VPWR VGND sky130_fd_sc_hd__edfxtp_1
XFILLER_56_289 VGND VPWR VPWR VGND sky130_fd_sc_hd__decap_12
XFILLER_24_153 VGND VPWR VPWR VGND sky130_fd_sc_hd__decap_4
XFILLER_24_197 VGND VPWR VPWR VGND sky130_fd_sc_hd__decap_12
XFILLER_20_381 VPWR VGND VPWR VGND sky130_fd_sc_hd__decap_8
XFILLER_47_267 VPWR VGND VPWR VGND sky130_fd_sc_hd__decap_8
XFILLER_15_131 VPWR VGND VPWR VGND sky130_fd_sc_hd__decap_8
X_1671_ VPWR VGND VGND VPWR _1671_/A _1671_/Y sky130_fd_sc_hd__inv_1
X_1740_ VPWR VGND _1788_/CLK _1742_/DE _1740_/Q _1740_/D VPWR VGND sky130_fd_sc_hd__edfxtp_1
XFILLER_7_385 VPWR VGND VPWR VGND sky130_fd_sc_hd__decap_6
XFILLER_53_215 VPWR VGND VPWR VGND sky130_fd_sc_hd__decap_3
X_1105_ VGND VPWR VGND VPWR _1827_/Q _1735_/Q _1703_/Q _1828_/Q _1767_/Q _1799_/Q
+ _1105_/X sky130_fd_sc_hd__mux4_2
X_1036_ VPWR VGND VGND VPWR _1035_/X _1036_/Y _1034_/X _1084_/S sky130_fd_sc_hd__mux2i_1
X_1869_ VPWR VGND _1994_/CLK _1869_/DE _1869_/Q _1869_/D VPWR VGND sky130_fd_sc_hd__edfxtp_1
X_1938_ _1938_/Q _1982_/CLK _1938_/D VPWR VGND VPWR VGND sky130_fd_sc_hd__dfxtp_1
XFILLER_67_27 VGND VPWR VPWR VGND sky130_fd_sc_hd__decap_12
XPHY_EDGE_ROW_57_Left_129 VPWR VGND VPWR VGND sky130_fd_sc_hd__decap_3
XFILLER_52_292 VPWR VGND VPWR VGND sky130_fd_sc_hd__decap_8
XFILLER_40_421 VGND VPWR VPWR VGND sky130_fd_sc_hd__decap_4
XFILLER_8_149 VPWR VGND VPWR VGND sky130_fd_sc_hd__decap_3
XFILLER_4_377 VGND VPWR VPWR VGND sky130_fd_sc_hd__decap_12
XFILLER_4_333 VGND VPWR VPWR VGND sky130_fd_sc_hd__decap_12
XPHY_EDGE_ROW_66_Left_138 VPWR VGND VPWR VGND sky130_fd_sc_hd__decap_3
XFILLER_35_237 VGND VPWR VPWR VGND sky130_fd_sc_hd__decap_12
XFILLER_43_281 VPWR VGND VPWR VGND sky130_fd_sc_hd__decap_6
XFILLER_31_421 VGND VPWR VPWR VGND sky130_fd_sc_hd__decap_4
X_1654_ VPWR VGND VGND VPWR _1691_/A _1654_/Y sky130_fd_sc_hd__inv_1
X_1723_ VPWR VGND clkload2/A _1726_/DE _1723_/Q _1723_/D VPWR VGND sky130_fd_sc_hd__edfxtp_1
X_1585_ VPWR VGND VGND VPWR _1689_/A _1585_/B _1963_/D sky130_fd_sc_hd__nor2_1
X_1019_ VPWR VGND VGND VPWR _1963_/Q _1353_/B _1358_/C sky130_fd_sc_hd__nor2_1
XFILLER_41_229 VGND VPWR VPWR VGND sky130_fd_sc_hd__decap_4
XFILLER_22_410 VPWR VGND VPWR VGND sky130_fd_sc_hd__decap_8
XFILLER_22_421 VGND VPWR VPWR VGND sky130_fd_sc_hd__decap_4
XFILLER_4_141 VGND VPWR VPWR VGND sky130_fd_sc_hd__decap_12
X_1370_ VGND VPWR VPWR VGND _1778_/D _1629_/B _1846_/Q sky130_fd_sc_hd__and2_0
Xinput292 VPWR VGND _1584_/A1 mem_rdata[15] VPWR VGND sky130_fd_sc_hd__buf_4
X_1706_ VPWR VGND _2015_/CLK _1710_/DE _1706_/Q _1706_/D VPWR VGND sky130_fd_sc_hd__edfxtp_1
X_1637_ VPWR VGND VGND VPWR _1645_/A _1637_/Y sky130_fd_sc_hd__inv_1
X_1568_ VGND VPWR _1573_/B _1569_/B _2022_/A VPWR VGND sky130_fd_sc_hd__xnor2_1
XFILLER_48_29 VPWR VGND VPWR VGND sky130_fd_sc_hd__decap_3
X_1499_ VPWR VGND VGND VPWR _1219_/A _1500_/B _1499_/A1 _1499_/S sky130_fd_sc_hd__mux2i_1
XFILLER_39_384 VPWR VGND VPWR VGND sky130_fd_sc_hd__decap_8
XFILLER_54_343 VGND VPWR VPWR VGND sky130_fd_sc_hd__decap_12
XFILLER_10_413 VPWR VGND VPWR VGND sky130_fd_sc_hd__decap_6
Xfanout99 VPWR VGND _1645_/A _1647_/A VPWR VGND sky130_fd_sc_hd__buf_2
XFILLER_8_3 VGND VPWR VPWR VGND sky130_fd_sc_hd__decap_12
XFILLER_64_129 VPWR VGND VPWR VGND sky130_fd_sc_hd__decap_3
X_0870_ VPWR VGND VGND VPWR _1995_/Q _0870_/B _0873_/B sky130_fd_sc_hd__nor2_1
X_1422_ VGND VPWR VPWR VGND _1722_/D _1526_/B _1854_/Q sky130_fd_sc_hd__and2_0
Xclkload14 VGND VPWR VPWR VGND _2007_/CLK clkload14/Y sky130_fd_sc_hd__clkinvlp_4
X_1353_ VPWR VGND VGND VPWR _1353_/Y _1353_/D _1353_/C _1353_/B _1963_/Q sky130_fd_sc_hd__nor4_1
X_1284_ VGND VPWR VGND VPWR _1328_/B _1283_/A _1284_/Y _1283_/B sky130_fd_sc_hd__o21ai_0
Xplace195 VPWR VGND _1606_/C _1565_/A VPWR VGND sky130_fd_sc_hd__buf_2
XFILLER_63_184 VGND VPWR VPWR VGND sky130_fd_sc_hd__decap_4
Xclkload8 VGND VPWR clkload8/A clkload8/X VPWR VGND sky130_fd_sc_hd__clkbuf_4
X_0999_ VGND VPWR _1874_/Q _0999_/Y _1919_/Q VPWR VGND sky130_fd_sc_hd__xnor2_1
XFILLER_59_413 VPWR VGND VPWR VGND sky130_fd_sc_hd__decap_6
XFILLER_39_181 VPWR VGND VPWR VGND sky130_fd_sc_hd__decap_8
XFILLER_6_258 VGND VPWR VPWR VGND sky130_fd_sc_hd__decap_12
XFILLER_1_57 VGND VPWR VPWR VGND sky130_fd_sc_hd__decap_12
X_1971_ _2023_/A _1983_/CLK _1971_/D VPWR VGND VPWR VGND sky130_fd_sc_hd__dfxtp_1
XFILLER_60_3 VGND VPWR VPWR VGND sky130_fd_sc_hd__decap_12
X_0853_ VGND VPWR VGND VPWR _1996_/Q _1997_/Q _0853_/Y _1995_/Q _0974_/A sky130_fd_sc_hd__nor4_2
X_0922_ VPWR VGND VPWR VGND _1887_/Q _1997_/Q _1366_/B1 _0922_/Y sky130_fd_sc_hd__a21oi_1
X_1405_ VGND VPWR VPWR VGND _1740_/D _1527_/B _1856_/Q sky130_fd_sc_hd__and2_0
XFILLER_68_265 VGND VPWR VPWR VGND sky130_fd_sc_hd__decap_4
X_1198_ VGND VPWR _1198_/B _1199_/B _1198_/A VPWR VGND sky130_fd_sc_hd__xnor2_1
X_1267_ VPWR VGND VPWR VGND _1977_/Q _1890_/Q _1328_/B _1267_/Y _1893_/Q sky130_fd_sc_hd__nand4_1
XFILLER_56_405 VPWR VGND VPWR VGND sky130_fd_sc_hd__decap_3
X_1336_ VPWR VGND VGND VPWR _1336_/Y _1357_/B _1357_/C _1357_/A sky130_fd_sc_hd__nand3b_1
XFILLER_3_217 VPWR VGND VPWR VGND sky130_fd_sc_hd__decap_6
XFILLER_47_405 VPWR VGND VPWR VGND sky130_fd_sc_hd__decap_3
XFILLER_51_62 VGND VPWR VPWR VGND sky130_fd_sc_hd__decap_4
XPHY_EDGE_ROW_27_Left_99 VPWR VGND VPWR VGND sky130_fd_sc_hd__decap_3
X_1052_ VPWR VGND VGND VPWR _1309_/A _1052_/Y _1085_/B sky130_fd_sc_hd__nand2_1
X_1121_ VGND VPWR VGND VPWR _1127_/S0 _1746_/Q _1714_/Q _1127_/S1 _1778_/Q _1810_/Q
+ _1121_/X sky130_fd_sc_hd__mux4_2
X_1954_ _1954_/Q _1954_/CLK _1954_/D VPWR VGND VPWR VGND sky130_fd_sc_hd__dfxtp_1
XFILLER_18_184 VGND VPWR VPWR VGND sky130_fd_sc_hd__decap_12
X_0836_ VPWR VGND VGND VPWR _1961_/Q _1331_/B sky130_fd_sc_hd__inv_1
X_0905_ VGND VPWR VPWR VGND _1882_/Q _0954_/B _0906_/B sky130_fd_sc_hd__xor2_1
X_1885_ VPWR VGND _1997_/CLK _1932_/DE _1885_/Q _1885_/D VPWR VGND sky130_fd_sc_hd__edfxtp_1
XFILLER_0_209 VGND VPWR VPWR VGND sky130_fd_sc_hd__decap_12
X_1319_ VPWR VGND VGND VPWR _1872_/Q _1319_/B _1319_/Y sky130_fd_sc_hd__nor2_1
XFILLER_24_132 VPWR VGND VPWR VGND sky130_fd_sc_hd__decap_8
XFILLER_8_309 VGND VPWR VPWR VGND sky130_fd_sc_hd__decap_12
XFILLER_62_61 VGND VPWR VPWR VGND sky130_fd_sc_hd__decap_4
XFILLER_15_187 VGND VPWR VPWR VGND sky130_fd_sc_hd__decap_4
X_1670_ VPWR VGND VGND VPWR _1693_/A _1670_/Y sky130_fd_sc_hd__inv_1
XFILLER_11_393 VGND VPWR VPWR VGND sky130_fd_sc_hd__decap_12
XFILLER_23_3 VPWR VGND VPWR VGND sky130_fd_sc_hd__decap_3
XFILLER_38_246 VPWR VGND VPWR VGND sky130_fd_sc_hd__decap_6
X_1035_ VGND VPWR VGND VPWR _1059_/S0 _1785_/Q _1769_/Q _1064_/S1 _1801_/Q _1817_/Q
+ _1035_/X sky130_fd_sc_hd__mux4_2
X_1104_ VGND VPWR VPWR VGND _1883_/D _1102_/X _1131_/S _1103_/X sky130_fd_sc_hd__mux2_1
X_1937_ _1937_/Q _1967_/CLK _1937_/D VPWR VGND VPWR VGND sky130_fd_sc_hd__dfxtp_1
X_1868_ VPWR VGND _1994_/CLK _1869_/DE _1868_/Q _1868_/D VPWR VGND sky130_fd_sc_hd__edfxtp_1
X_1799_ VPWR VGND _2015_/CLK _1806_/DE _1799_/Q _1799_/D VPWR VGND sky130_fd_sc_hd__edfxtp_1
XFILLER_69_393 VGND VPWR VPWR VGND sky130_fd_sc_hd__decap_12
XFILLER_69_382 VPWR VGND VPWR VGND sky130_fd_sc_hd__decap_8
XFILLER_69_360 VPWR VGND VPWR VGND sky130_fd_sc_hd__decap_6
XFILLER_67_39 VGND VPWR VPWR VGND sky130_fd_sc_hd__decap_12
XFILLER_44_249 VPWR VGND VPWR VGND sky130_fd_sc_hd__decap_3
XFILLER_16_43 VGND VPWR VPWR VGND sky130_fd_sc_hd__decap_12
XFILLER_16_65 VGND VPWR VPWR VGND sky130_fd_sc_hd__decap_12
XFILLER_4_301 VPWR VGND VPWR VGND sky130_fd_sc_hd__decap_6
XFILLER_4_389 VGND VPWR VPWR VGND sky130_fd_sc_hd__decap_12
XFILLER_4_345 VGND VPWR VPWR VGND sky130_fd_sc_hd__decap_12
XFILLER_35_205 VGND VPWR VPWR VGND sky130_fd_sc_hd__decap_12
XFILLER_43_260 VPWR VGND VPWR VGND sky130_fd_sc_hd__decap_8
XFILLER_31_411 VPWR VGND VPWR VGND sky130_fd_sc_hd__decap_6
X_1653_ VPWR VGND VGND VPWR _1673_/A _1653_/Y sky130_fd_sc_hd__inv_1
X_1584_ VPWR VGND VGND VPWR _1963_/Q _1585_/B _1584_/A1 _1584_/S sky130_fd_sc_hd__mux2i_1
X_1722_ VPWR VGND _2015_/CLK _1726_/DE _1722_/Q _1722_/D VPWR VGND sky130_fd_sc_hd__edfxtp_1
XFILLER_7_150 VGND VPWR VPWR VGND sky130_fd_sc_hd__decap_12
XPHY_EDGE_ROW_9_Right_9 VPWR VGND VPWR VGND sky130_fd_sc_hd__decap_3
X_1018_ VPWR VGND VGND VPWR _1353_/B _1342_/B _1018_/B sky130_fd_sc_hd__nand2_1
XFILLER_41_219 VGND VPWR VPWR VGND sky130_fd_sc_hd__decap_4
XPHY_EDGE_ROW_14_Left_86 VPWR VGND VPWR VGND sky130_fd_sc_hd__decap_3
XFILLER_1_337 VGND VPWR VPWR VGND sky130_fd_sc_hd__decap_12
XFILLER_27_53 VPWR VGND VPWR VGND sky130_fd_sc_hd__decap_3
XFILLER_40_274 VPWR VGND VPWR VGND sky130_fd_sc_hd__decap_8
XFILLER_4_153 VGND VPWR VPWR VGND sky130_fd_sc_hd__decap_12
XFILLER_67_138 VGND VPWR VPWR VGND sky130_fd_sc_hd__decap_4
XFILLER_4_197 VGND VPWR VPWR VGND sky130_fd_sc_hd__decap_12
XFILLER_48_374 VGND VPWR VPWR VGND sky130_fd_sc_hd__decap_4
Xinput293 VPWR VGND _1499_/A1 mem_rdata[1] VPWR VGND sky130_fd_sc_hd__buf_4
X_1705_ VPWR VGND clkload1/A _1710_/DE _1705_/Q _1705_/D VPWR VGND sky130_fd_sc_hd__edfxtp_1
X_1567_ VPWR VGND VPWR VGND _1566_/Y _1565_/Y _1688_/A _1971_/D sky130_fd_sc_hd__a21oi_1
X_1636_ VPWR VGND VGND VPWR _1645_/A _1636_/Y sky130_fd_sc_hd__inv_1
XFILLER_64_29 VGND VPWR VPWR VGND sky130_fd_sc_hd__decap_4
X_1498_ VPWR VGND VGND VPWR _1522_/A _1498_/B _1950_/D sky130_fd_sc_hd__nor2_1
XFILLER_38_41 VGND VPWR VPWR VGND sky130_fd_sc_hd__decap_12
XFILLER_60_336 VPWR VGND VPWR VGND sky130_fd_sc_hd__decap_8
XFILLER_38_85 VPWR VGND VPWR VGND sky130_fd_sc_hd__decap_3
XFILLER_60_369 VGND VPWR VPWR VGND sky130_fd_sc_hd__decap_4
Xclkload15 VGND VPWR VPWR VGND _1895_/CLK clkload15/Y sky130_fd_sc_hd__clkinvlp_4
XFILLER_68_403 VGND VPWR VPWR VGND sky130_fd_sc_hd__decap_12
X_1421_ VGND VPWR VPWR VGND _1723_/D _1526_/B _1855_/Q sky130_fd_sc_hd__and2_0
XFILLER_48_193 VPWR VGND VPWR VGND sky130_fd_sc_hd__decap_3
X_1352_ VPWR VGND _1169_/Y _1353_/D _1331_/Y _2000_/D _1351_/Y VPWR VGND sky130_fd_sc_hd__o31ai_1
X_1283_ VPWR VGND VGND VPWR _1283_/A _1283_/B _1283_/Y sky130_fd_sc_hd__nor2_1
Xplace196 VPWR VGND _1521_/S _1573_/A VPWR VGND sky130_fd_sc_hd__buf_2
Xclkload9 VGND VPWR VPWR VGND clkload9/A clkload9/Y sky130_fd_sc_hd__clkinvlp_4
X_0998_ VGND VPWR VGND VPWR _1919_/Q _0998_/A1 _0998_/Y _0997_/X sky130_fd_sc_hd__o21ai_0
X_1619_ VGND VPWR VPWR VGND _1793_/D _1621_/B _1845_/Q sky130_fd_sc_hd__and2_0
XFILLER_54_141 VGND VPWR VPWR VGND sky130_fd_sc_hd__decap_4
XFILLER_42_325 VGND VPWR VPWR VGND sky130_fd_sc_hd__decap_12
XFILLER_42_303 VGND VPWR VPWR VGND sky130_fd_sc_hd__decap_4
XFILLER_10_277 VPWR VGND VPWR VGND sky130_fd_sc_hd__decap_8
XFILLER_2_421 VGND VPWR VPWR VGND sky130_fd_sc_hd__decap_4
XFILLER_6_248 VGND VPWR VPWR VGND sky130_fd_sc_hd__decap_4
XFILLER_65_406 VPWR VGND VPWR VGND sky130_fd_sc_hd__decap_8
XFILLER_1_69 VGND VPWR VPWR VGND sky130_fd_sc_hd__decap_12
X_1970_ _2022_/A _1983_/CLK _1970_/D VPWR VGND VPWR VGND sky130_fd_sc_hd__dfxtp_1
X_0921_ VPWR VGND VGND VPWR _0839_/Y _0854_/Y _0920_/X _1367_/A1 _1992_/D sky130_fd_sc_hd__o22ai_1
XFILLER_33_325 VPWR VGND VPWR VGND sky130_fd_sc_hd__decap_8
XFILLER_53_3 VGND VPWR VPWR VGND sky130_fd_sc_hd__decap_4
X_0852_ VPWR VGND VGND VPWR _1995_/Q _1996_/Q _0852_/Y sky130_fd_sc_hd__nor2_1
X_1335_ VPWR VGND VGND VPWR _1538_/B _1357_/C _1360_/C _1353_/D sky130_fd_sc_hd__nor3b_2
X_1404_ VGND VPWR VPWR VGND _1741_/D _1527_/B _1857_/Q sky130_fd_sc_hd__and2_0
X_1197_ VGND VPWR VPWR VGND _1941_/Q _1198_/B _1953_/Q sky130_fd_sc_hd__xor2_1
XFILLER_56_417 VPWR VGND VPWR VGND sky130_fd_sc_hd__decap_3
X_1266_ VPWR VGND VGND VPWR _1266_/X _1658_/A _1593_/B sky130_fd_sc_hd__or2_1
XFILLER_51_177 VGND VPWR VPWR VGND sky130_fd_sc_hd__decap_12
XFILLER_59_211 VPWR VGND VPWR VGND sky130_fd_sc_hd__decap_6
XFILLER_42_188 VPWR VGND VPWR VGND sky130_fd_sc_hd__decap_8
XFILLER_15_314 VPWR VGND VPWR VGND sky130_fd_sc_hd__decap_3
XPHY_EDGE_ROW_2_Left_74 VPWR VGND VPWR VGND sky130_fd_sc_hd__decap_3
XFILLER_65_225 VPWR VGND VPWR VGND sky130_fd_sc_hd__decap_3
X_1051_ VGND VPWR VGND VPWR _1047_/Y _1086_/A1 _1926_/D _1050_/Y sky130_fd_sc_hd__o21ai_0
X_1120_ VGND VPWR VGND VPWR _1127_/S0 _1730_/Q _1698_/Q _1127_/S1 _1762_/Q _1794_/Q
+ _1120_/X sky130_fd_sc_hd__mux4_2
X_1953_ _1953_/Q _1983_/CLK _1953_/D VPWR VGND VPWR VGND sky130_fd_sc_hd__dfxtp_1
X_0904_ VPWR VGND VGND VPWR _0954_/A _0960_/A _1881_/Q _0904_/B sky130_fd_sc_hd__maj3_1
X_1884_ VPWR VGND _1995_/CLK _1932_/DE _1884_/Q _1884_/D VPWR VGND sky130_fd_sc_hd__edfxtp_1
X_0835_ VPWR VGND VGND VPWR _1959_/Q _0835_/Y sky130_fd_sc_hd__inv_1
XFILLER_56_225 VPWR VGND VPWR VGND sky130_fd_sc_hd__decap_3
X_1318_ VPWR VGND VPWR VGND _1319_/B _1872_/Q _1302_/B _1318_/Y sky130_fd_sc_hd__a21oi_1
XFILLER_29_417 VPWR VGND VPWR VGND sky130_fd_sc_hd__decap_3
X_1249_ VGND VPWR VPWR VGND _1249_/X _2021_/A _1253_/S _1982_/Q sky130_fd_sc_hd__mux2_1
XFILLER_44_409 VPWR VGND VPWR VGND sky130_fd_sc_hd__decap_8
XFILLER_47_225 VGND VPWR VPWR VGND sky130_fd_sc_hd__decap_12
XFILLER_46_85 VPWR VGND VPWR VGND sky130_fd_sc_hd__decap_3
XFILLER_46_74 VGND VPWR VPWR VGND sky130_fd_sc_hd__decap_4
XFILLER_46_96 VPWR VGND VPWR VGND sky130_fd_sc_hd__decap_8
XFILLER_7_57 VGND VPWR VPWR VGND sky130_fd_sc_hd__decap_12
XFILLER_16_3 VGND VPWR VPWR VGND sky130_fd_sc_hd__decap_12
XFILLER_61_261 VGND VPWR VPWR VGND sky130_fd_sc_hd__decap_12
X_1034_ VGND VPWR VGND VPWR _1059_/S0 _1721_/Q _1705_/Q _1064_/S1 _1737_/Q _1753_/Q
+ _1034_/X sky130_fd_sc_hd__mux4_2
X_1103_ VGND VPWR VGND VPWR _1130_/S0 _1752_/Q _1720_/Q _1130_/S1 _1784_/Q _1816_/Q
+ _1103_/X sky130_fd_sc_hd__mux4_2
X_1867_ VPWR VGND _1994_/CLK _1869_/DE _1867_/Q _1867_/D VPWR VGND sky130_fd_sc_hd__edfxtp_1
X_1936_ _1936_/Q _1983_/CLK _1936_/D VPWR VGND VPWR VGND sky130_fd_sc_hd__dfxtp_1
XFILLER_21_169 VPWR VGND VPWR VGND sky130_fd_sc_hd__decap_8
X_1798_ VPWR VGND _1807_/CLK _1801_/DE _1798_/Q _1798_/D VPWR VGND sky130_fd_sc_hd__edfxtp_1
XFILLER_44_217 VGND VPWR VPWR VGND sky130_fd_sc_hd__decap_12
XFILLER_29_225 VPWR VGND VPWR VGND sky130_fd_sc_hd__decap_6
XFILLER_16_55 VGND VPWR VPWR VGND sky130_fd_sc_hd__decap_4
XFILLER_16_77 VPWR VGND VPWR VGND sky130_fd_sc_hd__decap_6
XFILLER_4_357 VPWR VGND VPWR VGND sky130_fd_sc_hd__decap_6
XFILLER_43_294 VGND VPWR VPWR VGND sky130_fd_sc_hd__decap_12
XFILLER_43_272 VPWR VGND VPWR VGND sky130_fd_sc_hd__decap_8
X_1721_ VPWR VGND clkload1/A _1724_/DE _1721_/Q _1721_/D VPWR VGND sky130_fd_sc_hd__edfxtp_1
X_1652_ VPWR VGND VGND VPWR _1673_/A _1652_/Y sky130_fd_sc_hd__inv_1
XFILLER_7_162 VPWR VGND VPWR VGND sky130_fd_sc_hd__decap_6
X_1583_ VGND VPWR VPWR VGND _1820_/D _1598_/B _1856_/Q sky130_fd_sc_hd__and2_0
XFILLER_26_217 VPWR VGND VPWR VGND sky130_fd_sc_hd__decap_3
X_1017_ VPWR VGND _1305_/A _1018_/B _1962_/Q VPWR VGND sky130_fd_sc_hd__and2_1
X_1919_ VPWR VGND _1954_/CLK _2008_/DE _1919_/Q _1919_/D VPWR VGND sky130_fd_sc_hd__edfxtp_1
XFILLER_1_349 VGND VPWR VPWR VGND sky130_fd_sc_hd__decap_12
XFILLER_1_305 VGND VPWR VPWR VGND sky130_fd_sc_hd__decap_12
XFILLER_40_253 VPWR VGND VPWR VGND sky130_fd_sc_hd__decap_3
XFILLER_9_405 VGND VPWR VPWR VGND sky130_fd_sc_hd__decap_12
XFILLER_4_165 VGND VPWR VPWR VGND sky130_fd_sc_hd__decap_12
XFILLER_4_121 VGND VPWR VPWR VGND sky130_fd_sc_hd__decap_12
Xinput294 VPWR VGND _1497_/A1 mem_rdata[2] VPWR VGND sky130_fd_sc_hd__buf_4
XFILLER_0_393 VGND VPWR VPWR VGND sky130_fd_sc_hd__decap_12
X_1704_ VPWR VGND _1788_/CLK _1708_/DE _1704_/Q _1704_/D VPWR VGND sky130_fd_sc_hd__edfxtp_1
X_1566_ VPWR VGND VPWR VGND _2023_/A _1460_/B _1566_/Y hold412/X _1459_/B sky130_fd_sc_hd__a22oi_1
XFILLER_58_106 VGND VPWR VPWR VGND sky130_fd_sc_hd__decap_4
X_1497_ VPWR VGND VGND VPWR _1157_/B _1498_/B _1497_/A1 _1499_/S sky130_fd_sc_hd__mux2i_1
X_1635_ VPWR VGND VGND VPWR _1658_/A _1635_/Y sky130_fd_sc_hd__inv_1
XFILLER_39_320 VGND VPWR VPWR VGND sky130_fd_sc_hd__decap_12
XFILLER_14_209 VPWR VGND VPWR VGND sky130_fd_sc_hd__decap_8
XFILLER_22_253 VGND VPWR VPWR VGND sky130_fd_sc_hd__decap_12
XFILLER_1_113 VGND VPWR VPWR VGND sky130_fd_sc_hd__decap_12
XFILLER_60_315 VGND VPWR VPWR VGND sky130_fd_sc_hd__decap_4
Xclkload16 VGND VPWR _1988_/CLK clkload16/Y VPWR VGND sky130_fd_sc_hd__clkinvlp_2
XFILLER_68_415 VGND VPWR VPWR VGND sky130_fd_sc_hd__decap_4
X_1351_ VPWR VGND VGND VPWR _1351_/A _1351_/Y _1353_/D sky130_fd_sc_hd__nand2_1
X_1420_ VGND VPWR VPWR VGND _1724_/D _1433_/B _1856_/Q sky130_fd_sc_hd__and2_0
XFILLER_63_164 VGND VPWR VPWR VGND sky130_fd_sc_hd__decap_4
XFILLER_55_109 VPWR VGND VPWR VGND sky130_fd_sc_hd__decap_3
XFILLER_51_304 VPWR VGND VPWR VGND sky130_fd_sc_hd__decap_3
X_1282_ VGND VPWR VGND VPWR _1328_/B _1281_/A _1282_/Y _1281_/B sky130_fd_sc_hd__o21ai_0
Xplace197 VPWR VGND _1499_/S _1573_/A VPWR VGND sky130_fd_sc_hd__buf_2
XFILLER_51_337 VPWR VGND VPWR VGND sky130_fd_sc_hd__decap_3
XFILLER_51_326 VPWR VGND VPWR VGND sky130_fd_sc_hd__decap_8
XFILLER_51_315 VPWR VGND VPWR VGND sky130_fd_sc_hd__decap_6
X_0997_ VGND VPWR VPWR VGND _0997_/X _1874_/Q _0997_/A sky130_fd_sc_hd__and2_0
X_1618_ VGND VPWR VPWR VGND _1794_/D _1621_/B _1846_/Q sky130_fd_sc_hd__and2_0
X_1549_ VPWR VGND VPWR VGND _1548_/Y _1553_/B _1671_/A _1549_/Y sky130_fd_sc_hd__a21oi_1
XFILLER_39_150 VPWR VGND VPWR VGND sky130_fd_sc_hd__decap_8
XFILLER_54_197 VGND VPWR VPWR VGND sky130_fd_sc_hd__decap_12
XFILLER_54_131 VPWR VGND VPWR VGND sky130_fd_sc_hd__decap_3
XFILLER_40_21 VPWR VGND VPWR VGND sky130_fd_sc_hd__decap_6
XFILLER_24_77 VPWR VGND VPWR VGND sky130_fd_sc_hd__decap_6
XFILLER_49_52 VGND VPWR VPWR VGND sky130_fd_sc_hd__decap_4
XFILLER_65_84 VPWR VGND VPWR VGND sky130_fd_sc_hd__decap_8
XFILLER_1_15 VGND VPWR VPWR VGND sky130_fd_sc_hd__decap_12
XFILLER_18_356 VPWR VGND VPWR VGND sky130_fd_sc_hd__decap_8
XFILLER_60_134 VPWR VGND VPWR VGND sky130_fd_sc_hd__decap_6
X_0920_ VGND VPWR VPWR VGND _1361_/B _0920_/X _0920_/B sky130_fd_sc_hd__xor2_1
XFILLER_33_337 VGND VPWR VPWR VGND sky130_fd_sc_hd__decap_12
XFILLER_18_389 VPWR VGND VPWR VGND sky130_fd_sc_hd__decap_3
X_0851_ VPWR VGND VGND VPWR _1934_/Q _0851_/Y sky130_fd_sc_hd__inv_1
X_1334_ VGND VPWR VPWR VGND _1006_/Y _1133_/A _1357_/A _1360_/C _1358_/C sky130_fd_sc_hd__a31oi_1
X_1265_ VPWR VGND VGND VPWR _1281_/A _1891_/Q _1892_/Q _1265_/Y sky130_fd_sc_hd__nor3_1
XPHY_EDGE_ROW_18_Right_18 VPWR VGND VPWR VGND sky130_fd_sc_hd__decap_3
X_1403_ VGND VPWR VPWR VGND _1743_/D _1528_/B _1843_/Q sky130_fd_sc_hd__and2_0
X_1196_ VPWR VGND VPWR VGND _1221_/B _1880_/D _1195_/Y _1865_/D sky130_fd_sc_hd__a21o_1
XPHY_EDGE_ROW_27_Right_27 VPWR VGND VPWR VGND sky130_fd_sc_hd__decap_3
XPHY_EDGE_ROW_36_Right_36 VPWR VGND VPWR VGND sky130_fd_sc_hd__decap_3
Xoutput340 VPWR VGND mem_wdata[7] _2036_/X VPWR VGND sky130_fd_sc_hd__buf_4
XFILLER_19_88 VPWR VGND VPWR VGND sky130_fd_sc_hd__decap_6
XFILLER_70_421 VGND VPWR VPWR VGND sky130_fd_sc_hd__decap_4
XPHY_EDGE_ROW_45_Right_45 VPWR VGND VPWR VGND sky130_fd_sc_hd__decap_3
XFILLER_42_134 VPWR VGND VPWR VGND sky130_fd_sc_hd__decap_6
XFILLER_15_337 VGND VPWR VPWR VGND sky130_fd_sc_hd__decap_4
XPHY_EDGE_ROW_54_Right_54 VPWR VGND VPWR VGND sky130_fd_sc_hd__decap_3
XFILLER_2_285 VGND VPWR VPWR VGND sky130_fd_sc_hd__decap_12
XPHY_EDGE_ROW_63_Right_63 VPWR VGND VPWR VGND sky130_fd_sc_hd__decap_3
X_1050_ VPWR VGND VGND VPWR _1049_/X _1050_/Y _1048_/X _1084_/S sky130_fd_sc_hd__mux2i_1
XFILLER_18_197 VGND VPWR VPWR VGND sky130_fd_sc_hd__decap_12
X_0834_ VPWR VGND VGND VPWR _2024_/A _1543_/A sky130_fd_sc_hd__inv_1
X_0903_ VGND VPWR VPWR VGND _1881_/Q _0960_/B _0904_/B sky130_fd_sc_hd__xor2_1
X_1952_ _1952_/Q _1979_/CLK _1952_/D VPWR VGND VPWR VGND sky130_fd_sc_hd__dfxtp_1
X_1883_ VPWR VGND _1995_/CLK _1926_/DE _1883_/Q _1883_/D VPWR VGND sky130_fd_sc_hd__edfxtp_1
XFILLER_14_381 VPWR VGND VPWR VGND sky130_fd_sc_hd__decap_8
X_1248_ VGND VPWR VPWR VGND _1248_/X _2022_/A _1253_/S _1983_/Q sky130_fd_sc_hd__mux2_1
X_1317_ VPWR VGND VGND VPWR _1324_/B _1317_/D _1317_/C _1317_/B _1317_/A sky130_fd_sc_hd__nor4_1
XFILLER_64_270 VPWR VGND VPWR VGND sky130_fd_sc_hd__decap_3
X_1179_ VPWR VGND VPWR VGND _1166_/Y _1165_/Y _1178_/Y _1179_/Y sky130_fd_sc_hd__a21oi_1
XFILLER_52_421 VGND VPWR VPWR VGND sky130_fd_sc_hd__decap_4
XFILLER_55_281 VPWR VGND VPWR VGND sky130_fd_sc_hd__decap_3
XFILLER_55_270 VGND VPWR VPWR VGND sky130_fd_sc_hd__decap_4
XFILLER_47_237 VGND VPWR VPWR VGND sky130_fd_sc_hd__decap_4
XFILLER_62_85 VPWR VGND VPWR VGND sky130_fd_sc_hd__decap_6
XFILLER_7_69 VGND VPWR VPWR VGND sky130_fd_sc_hd__decap_12
X_1102_ VGND VPWR VGND VPWR _1130_/S0 _1736_/Q _1704_/Q _1130_/S1 _1768_/Q _1800_/Q
+ _1102_/X sky130_fd_sc_hd__mux4_2
XFILLER_61_273 VPWR VGND VPWR VGND sky130_fd_sc_hd__decap_3
X_1033_ VGND VPWR VGND VPWR _1288_/B1 _1288_/A1 _1930_/D _1032_/Y sky130_fd_sc_hd__o21ai_0
XFILLER_34_421 VGND VPWR VPWR VGND sky130_fd_sc_hd__decap_4
X_1866_ VPWR VGND _1986_/CLK _1869_/DE _1866_/Q _1866_/D VPWR VGND sky130_fd_sc_hd__edfxtp_1
X_1935_ _1935_/Q clkload8/A _1935_/D VPWR VGND VPWR VGND sky130_fd_sc_hd__dfxtp_1
X_1797_ VPWR VGND _1925_/CLK _1801_/DE _1797_/Q _1797_/D VPWR VGND sky130_fd_sc_hd__edfxtp_1
XFILLER_44_229 VGND VPWR VPWR VGND sky130_fd_sc_hd__decap_12
XFILLER_37_281 VGND VPWR VPWR VGND sky130_fd_sc_hd__decap_12
XFILLER_29_204 VGND VPWR VPWR VGND sky130_fd_sc_hd__decap_12
XFILLER_52_273 VPWR VGND VPWR VGND sky130_fd_sc_hd__decap_3
XPHY_EDGE_ROW_0_Right_0 VPWR VGND VPWR VGND sky130_fd_sc_hd__decap_3
XFILLER_57_30 VPWR VGND VPWR VGND sky130_fd_sc_hd__decap_6
XPHY_EDGE_ROW_35_Left_107 VPWR VGND VPWR VGND sky130_fd_sc_hd__decap_3
XFILLER_16_421 VGND VPWR VPWR VGND sky130_fd_sc_hd__decap_4
X_1651_ VPWR VGND VGND VPWR _1673_/A _1651_/Y sky130_fd_sc_hd__inv_1
XPHY_EDGE_ROW_44_Left_116 VPWR VGND VPWR VGND sky130_fd_sc_hd__decap_3
X_1720_ VPWR VGND _1788_/CLK _1724_/DE _1720_/Q _1720_/D VPWR VGND sky130_fd_sc_hd__edfxtp_1
X_1582_ VPWR VGND VGND VPWR _1679_/A _1582_/B _1947_/D sky130_fd_sc_hd__nor2_1
XFILLER_66_365 VPWR VGND VPWR VGND sky130_fd_sc_hd__decap_3
XFILLER_66_321 VGND VPWR VPWR VGND sky130_fd_sc_hd__decap_12
XPHY_EDGE_ROW_53_Left_125 VPWR VGND VPWR VGND sky130_fd_sc_hd__decap_3
XFILLER_19_281 VPWR VGND VPWR VGND sky130_fd_sc_hd__decap_6
X_1016_ VPWR VGND VGND VPWR _1963_/Q _1961_/Q _1018_/B sky130_fd_sc_hd__nor2_1
X_1918_ VPWR VGND clkload8/A _1673_/Y _1918_/Q _1918_/D VPWR VGND sky130_fd_sc_hd__edfxtp_1
XPHY_EDGE_ROW_62_Left_134 VPWR VGND VPWR VGND sky130_fd_sc_hd__decap_3
X_1849_ VPWR VGND _1979_/CLK _1665_/Y _1849_/Q _1849_/D VPWR VGND sky130_fd_sc_hd__edfxtp_1
XPHY_EDGE_ROW_71_Left_143 VPWR VGND VPWR VGND sky130_fd_sc_hd__decap_3
XFILLER_57_354 VGND VPWR VPWR VGND sky130_fd_sc_hd__decap_4
XFILLER_1_317 VGND VPWR VPWR VGND sky130_fd_sc_hd__decap_12
Xclkbuf_leaf_20_clk _1982_/CLK clkload0/A VPWR VGND VGND VPWR sky130_fd_sc_hd__clkbuf_8
XFILLER_9_417 VPWR VGND VPWR VGND sky130_fd_sc_hd__decap_3
XFILLER_4_177 VGND VPWR VPWR VGND sky130_fd_sc_hd__decap_4
XFILLER_4_133 VPWR VGND VPWR VGND sky130_fd_sc_hd__decap_6
XFILLER_4_15 VGND VPWR VPWR VGND sky130_fd_sc_hd__decap_12
XFILLER_48_365 VPWR VGND VPWR VGND sky130_fd_sc_hd__decap_6
XFILLER_48_343 VGND VPWR VPWR VGND sky130_fd_sc_hd__decap_12
Xinput295 VPWR VGND _1495_/A1 mem_rdata[3] VPWR VGND sky130_fd_sc_hd__buf_4
XFILLER_16_295 VGND VPWR VPWR VGND sky130_fd_sc_hd__decap_12
Xclkbuf_leaf_11_clk _1988_/CLK clkbuf_3_6__f_clk/X VPWR VGND VGND VPWR sky130_fd_sc_hd__clkbuf_8
X_1703_ VPWR VGND _2009_/CLK _1710_/DE _1703_/Q _1703_/D VPWR VGND sky130_fd_sc_hd__edfxtp_1
X_1634_ VPWR VGND VGND VPWR _1658_/A _1634_/Y sky130_fd_sc_hd__inv_1
X_1565_ VPWR VGND VGND VPWR _1565_/A _1565_/B _1565_/Y _1565_/C sky130_fd_sc_hd__nand3_1
X_1496_ VPWR VGND VGND VPWR _1522_/A _1496_/B _1951_/D sky130_fd_sc_hd__nor2_1
XFILLER_39_332 VGND VPWR VPWR VGND sky130_fd_sc_hd__decap_4
XFILLER_54_313 VGND VPWR VPWR VGND sky130_fd_sc_hd__decap_12
XFILLER_22_265 VGND VPWR VPWR VGND sky130_fd_sc_hd__decap_12
XFILLER_1_125 VGND VPWR VPWR VGND sky130_fd_sc_hd__decap_12
XFILLER_1_169 VGND VPWR VPWR VGND sky130_fd_sc_hd__decap_12
XFILLER_54_42 VGND VPWR VPWR VGND sky130_fd_sc_hd__decap_12
XFILLER_13_254 VPWR VGND VPWR VGND sky130_fd_sc_hd__decap_6
XFILLER_70_85 VGND VPWR VPWR VGND sky130_fd_sc_hd__decap_12
Xclkload17 VPWR VGND VGND VPWR _1987_/CLK clkload17/Y sky130_fd_sc_hd__clkinv_1
X_1350_ VGND VPWR VPWR VGND _1350_/X _2028_/A _1350_/S _1989_/Q sky130_fd_sc_hd__mux2_1
X_1281_ VPWR VGND VGND VPWR _1281_/B _1526_/B _1281_/A sky130_fd_sc_hd__nor2_2
XFILLER_36_324 VGND VPWR VPWR VGND sky130_fd_sc_hd__decap_4
Xclkbuf_leaf_0_clk _2009_/CLK clkbuf_leaf_2_clk/A VPWR VGND VGND VPWR sky130_fd_sc_hd__clkbuf_8
Xplace198 VPWR VGND _1573_/A _1565_/A VPWR VGND sky130_fd_sc_hd__buf_2
X_0996_ VPWR VGND VPWR VGND _0991_/Y _0992_/Y _1979_/D _0993_/X _1920_/Q _0995_/Y
+ sky130_fd_sc_hd__a221o_1
X_1617_ VGND VPWR VPWR VGND _1795_/D _1621_/B _1847_/Q sky130_fd_sc_hd__and2_0
X_1548_ VPWR VGND VGND VPWR _1547_/Y _1548_/Y _1869_/Q _1608_/A sky130_fd_sc_hd__mux2i_1
XFILLER_54_110 VPWR VGND VPWR VGND sky130_fd_sc_hd__decap_3
X_1479_ VPWR VGND VGND VPWR _1960_/Q _1480_/B _1479_/A1 _1584_/S sky130_fd_sc_hd__mux2i_1
XFILLER_40_77 VPWR VGND VPWR VGND sky130_fd_sc_hd__decap_6
XFILLER_10_224 VGND VPWR VPWR VGND sky130_fd_sc_hd__decap_12
XFILLER_49_75 VPWR VGND VPWR VGND sky130_fd_sc_hd__decap_6
XFILLER_6_3 VGND VPWR VPWR VGND sky130_fd_sc_hd__decap_12
XFILLER_2_401 VGND VPWR VPWR VGND sky130_fd_sc_hd__decap_12
XFILLER_65_41 VPWR VGND VPWR VGND sky130_fd_sc_hd__decap_3
XFILLER_45_165 VPWR VGND VPWR VGND sky130_fd_sc_hd__decap_3
XFILLER_1_27 VGND VPWR VPWR VGND sky130_fd_sc_hd__decap_12
XFILLER_60_179 VGND VPWR VPWR VGND sky130_fd_sc_hd__decap_12
X_0850_ VPWR VGND VGND VPWR _1264_/B _1328_/B sky130_fd_sc_hd__inv_1
XFILLER_41_393 VPWR VGND VPWR VGND sky130_fd_sc_hd__decap_3
X_1402_ VGND VPWR VPWR VGND _1744_/D _1402_/B _1844_/Q sky130_fd_sc_hd__and2_0
X_1333_ VPWR VGND VGND VPWR _1333_/A _1333_/Y _1353_/D sky130_fd_sc_hd__nand2_1
X_1264_ VGND VPWR VPWR VGND _1264_/B _1317_/A _1890_/Q _1281_/A sky130_fd_sc_hd__or3_2
X_1195_ VPWR VGND VPWR VGND _1193_/Y _1222_/C _1194_/Y _1195_/Y sky130_fd_sc_hd__a21oi_1
XFILLER_24_316 VPWR VGND VPWR VGND sky130_fd_sc_hd__decap_8
X_0979_ VPWR VGND VPWR VGND _0979_/X _0838_/Y _0973_/B _0978_/Y _0883_/A _0977_/Y
+ sky130_fd_sc_hd__o32a_1
XFILLER_59_235 VGND VPWR VPWR VGND sky130_fd_sc_hd__decap_12
Xoutput330 VPWR VGND mem_wdata[12] _2041_/X VPWR VGND sky130_fd_sc_hd__buf_4
Xoutput341 VPWR VGND mem_wdata[8] _2037_/X VPWR VGND sky130_fd_sc_hd__buf_4
XFILLER_50_190 VPWR VGND VPWR VGND sky130_fd_sc_hd__decap_6
XFILLER_2_231 VGND VPWR VPWR VGND sky130_fd_sc_hd__decap_12
XFILLER_2_297 VPWR VGND VPWR VGND sky130_fd_sc_hd__decap_8
XFILLER_2_253 VGND VPWR VPWR VGND sky130_fd_sc_hd__decap_12
XFILLER_33_113 VGND VPWR VPWR VGND sky130_fd_sc_hd__decap_12
X_0902_ VPWR VGND VGND VPWR _0960_/A _0965_/A _1880_/Q _0902_/B sky130_fd_sc_hd__maj3_1
X_1882_ VPWR VGND _1997_/CLK _1358_/D _1882_/Q _1882_/D VPWR VGND sky130_fd_sc_hd__edfxtp_1
X_1951_ _1951_/Q _1982_/CLK _1951_/D VPWR VGND VPWR VGND sky130_fd_sc_hd__dfxtp_1
X_1247_ VGND VPWR VPWR VGND _1247_/X _2023_/A _1253_/S _1984_/Q sky130_fd_sc_hd__mux2_1
X_1178_ VGND VPWR VGND VPWR _1339_/A1 _1165_/Y _1178_/Y _1166_/Y sky130_fd_sc_hd__o21ai_0
X_1316_ VGND VPWR _1319_/B _1317_/D _1891_/Q VPWR VGND sky130_fd_sc_hd__xnor2_1
XFILLER_62_208 VPWR VGND VPWR VGND sky130_fd_sc_hd__decap_8
XFILLER_15_102 VPWR VGND VPWR VGND sky130_fd_sc_hd__decap_8
XFILLER_7_15 VGND VPWR VPWR VGND sky130_fd_sc_hd__decap_12
X_1032_ VPWR VGND VGND VPWR _1031_/X _1032_/Y _1030_/X _1287_/S sky130_fd_sc_hd__mux2i_1
X_1101_ VGND VPWR VPWR VGND _1884_/D _1099_/X _1131_/S _1100_/X sky130_fd_sc_hd__mux2_1
X_1934_ VPWR VGND _1993_/CLK _2015_/DE _1934_/Q _1934_/D VPWR VGND sky130_fd_sc_hd__edfxtp_1
X_1865_ VPWR VGND _1983_/CLK _1869_/DE _1865_/Q _1865_/D VPWR VGND sky130_fd_sc_hd__edfxtp_1
X_1796_ VPWR VGND clkload4/A _1801_/DE _1796_/Q _1796_/D VPWR VGND sky130_fd_sc_hd__edfxtp_1
XFILLER_29_216 VPWR VGND VPWR VGND sky130_fd_sc_hd__decap_8
XFILLER_37_293 VGND VPWR VPWR VGND sky130_fd_sc_hd__decap_4
XFILLER_32_34 VPWR VGND VPWR VGND sky130_fd_sc_hd__decap_8
X_1581_ VPWR VGND VGND VPWR _1842_/D _1582_/B hold409/X _1606_/C sky130_fd_sc_hd__mux2i_1
X_1650_ VPWR VGND VGND VPWR _1694_/A _1650_/Y sky130_fd_sc_hd__inv_1
XFILLER_21_3 VGND VPWR VPWR VGND sky130_fd_sc_hd__decap_12
X_1015_ VPWR VGND VGND VPWR _1014_/X _1015_/Y _1013_/X _1287_/S sky130_fd_sc_hd__mux2i_1
X_1917_ VPWR VGND _1977_/CLK _1917_/DE _1917_/Q _1917_/D VPWR VGND sky130_fd_sc_hd__edfxtp_1
X_1848_ VPWR VGND _1986_/CLK _1666_/Y _1848_/Q _1848_/D VPWR VGND sky130_fd_sc_hd__edfxtp_1
X_1779_ VPWR VGND _1954_/CLK _1786_/DE _1779_/Q _1779_/D VPWR VGND sky130_fd_sc_hd__edfxtp_1
XFILLER_1_329 VPWR VGND VPWR VGND sky130_fd_sc_hd__decap_6
XFILLER_40_244 VPWR VGND VPWR VGND sky130_fd_sc_hd__decap_8
XFILLER_27_89 VPWR VGND VPWR VGND sky130_fd_sc_hd__decap_8
XFILLER_68_85 VPWR VGND VPWR VGND sky130_fd_sc_hd__decap_8
XFILLER_68_41 VPWR VGND VPWR VGND sky130_fd_sc_hd__decap_8
XFILLER_48_355 VPWR VGND VPWR VGND sky130_fd_sc_hd__decap_8
Xinput296 VPWR VGND _1493_/A1 mem_rdata[4] VPWR VGND sky130_fd_sc_hd__buf_4
XFILLER_31_277 VPWR VGND VPWR VGND sky130_fd_sc_hd__decap_3
XFILLER_69_3 VGND VPWR VPWR VGND sky130_fd_sc_hd__decap_12
X_1564_ VPWR VGND VPWR VGND _1542_/C _2022_/A _2023_/A _1565_/C sky130_fd_sc_hd__a21o_1
X_1633_ VPWR VGND VGND VPWR _1645_/A _1633_/Y sky130_fd_sc_hd__inv_1
X_1702_ VPWR VGND _1749_/CLK _1708_/DE _1702_/Q _1702_/D VPWR VGND sky130_fd_sc_hd__edfxtp_1
X_1495_ VPWR VGND VGND VPWR _1209_/B _1496_/B _1495_/A1 _1499_/S sky130_fd_sc_hd__mux2i_1
XFILLER_22_277 VPWR VGND VPWR VGND sky130_fd_sc_hd__decap_3
XFILLER_1_137 VGND VPWR VPWR VGND sky130_fd_sc_hd__decap_12
XFILLER_54_65 VPWR VGND VPWR VGND sky130_fd_sc_hd__decap_8
XFILLER_54_54 VGND VPWR VPWR VGND sky130_fd_sc_hd__decap_4
XFILLER_70_97 VGND VPWR VPWR VGND sky130_fd_sc_hd__decap_12
XFILLER_70_64 VGND VPWR VPWR VGND sky130_fd_sc_hd__decap_12
Xclkload18 VGND VPWR VPWR VGND _1986_/CLK clkload18/Y sky130_fd_sc_hd__clkinvlp_4
XFILLER_48_141 VGND VPWR VPWR VGND sky130_fd_sc_hd__decap_12
X_1280_ VGND VPWR VGND VPWR _1328_/B _1281_/A _1280_/Y _1283_/B sky130_fd_sc_hd__o21ai_0
XFILLER_0_181 VPWR VGND VPWR VGND sky130_fd_sc_hd__decap_8
XFILLER_63_144 VGND VPWR VPWR VGND sky130_fd_sc_hd__decap_12
XFILLER_44_391 VGND VPWR VPWR VGND sky130_fd_sc_hd__decap_12
XFILLER_44_380 VPWR VGND VPWR VGND sky130_fd_sc_hd__decap_3
XFILLER_36_369 VGND VPWR VPWR VGND sky130_fd_sc_hd__decap_12
XFILLER_36_347 VGND VPWR VPWR VGND sky130_fd_sc_hd__decap_4
Xplace199 VPWR VGND _1565_/A _1449_/Y VPWR VGND sky130_fd_sc_hd__buf_2
X_0995_ VPWR VGND VPWR VGND _1832_/Q _1831_/Q _0994_/Y _0995_/Y sky130_fd_sc_hd__a21oi_1
X_1547_ VPWR VGND VGND VPWR _2026_/A _2027_/A _1547_/Y _1606_/D sky130_fd_sc_hd__nand3_1
X_1616_ VGND VPWR VPWR VGND _1796_/D _1621_/B _1848_/Q sky130_fd_sc_hd__and2_0
X_1478_ VPWR VGND VGND VPWR _1689_/A _1478_/B _1961_/D sky130_fd_sc_hd__nor2_1
XFILLER_54_177 VPWR VGND VPWR VGND sky130_fd_sc_hd__decap_3
XFILLER_2_413 VPWR VGND VPWR VGND sky130_fd_sc_hd__decap_6
XFILLER_10_236 VGND VPWR VPWR VGND sky130_fd_sc_hd__decap_4
XFILLER_60_125 VGND VPWR VPWR VGND sky130_fd_sc_hd__decap_4
XFILLER_1_39 VGND VPWR VPWR VGND sky130_fd_sc_hd__decap_12
XFILLER_41_361 VGND VPWR VPWR VGND sky130_fd_sc_hd__decap_4
X_1401_ VGND VPWR VPWR VGND _1745_/D _1402_/B _1845_/Q sky130_fd_sc_hd__and2_0
X_1194_ VGND VPWR VGND VPWR _1207_/B _1309_/A _1194_/Y _1222_/C sky130_fd_sc_hd__o21ai_0
X_1263_ VPWR VGND VGND VPWR _1977_/Q _1317_/A _1893_/Q sky130_fd_sc_hd__nand2_1
X_1332_ VGND VPWR VPWR VGND _1358_/C _1331_/B _1960_/Q _1332_/Y _1305_/A sky130_fd_sc_hd__a31oi_1
XFILLER_32_361 VPWR VGND VPWR VGND sky130_fd_sc_hd__decap_3
X_0978_ VPWR VGND VPWR VGND _0931_/C _1834_/Q _1835_/Q _0978_/Y sky130_fd_sc_hd__a21oi_1
XFILLER_10_15 VGND VPWR VPWR VGND sky130_fd_sc_hd__decap_12
XFILLER_59_247 VGND VPWR VPWR VGND sky130_fd_sc_hd__decap_4
Xoutput320 VPWR VGND mem_addr[3] _1250_/X VPWR VGND sky130_fd_sc_hd__buf_4
Xoutput342 VPWR VGND mem_wdata[9] _2038_/X VPWR VGND sky130_fd_sc_hd__buf_4
Xoutput331 VPWR VGND mem_wdata[13] _2042_/X VPWR VGND sky130_fd_sc_hd__buf_4
XFILLER_10_48 VPWR VGND VPWR VGND sky130_fd_sc_hd__decap_6
XFILLER_10_59 VPWR VGND VPWR VGND sky130_fd_sc_hd__decap_8
XFILLER_27_199 VPWR VGND VPWR VGND sky130_fd_sc_hd__decap_8
XFILLER_30_309 VGND VPWR VPWR VGND sky130_fd_sc_hd__decap_4
XFILLER_2_265 VGND VPWR VPWR VGND sky130_fd_sc_hd__decap_12
XFILLER_2_243 VPWR VGND VPWR VGND sky130_fd_sc_hd__decap_8
XFILLER_58_291 VGND VPWR VPWR VGND sky130_fd_sc_hd__decap_4
X_1950_ _1950_/Q _1967_/CLK _1950_/D VPWR VGND VPWR VGND sky130_fd_sc_hd__dfxtp_1
XFILLER_33_169 VGND VPWR VPWR VGND sky130_fd_sc_hd__decap_12
XFILLER_33_125 VPWR VGND VPWR VGND sky130_fd_sc_hd__decap_8
X_1881_ VPWR VGND _1987_/CLK _1926_/DE _1881_/Q _1881_/D VPWR VGND sky130_fd_sc_hd__edfxtp_1
X_0901_ VGND VPWR VPWR VGND _1880_/Q _0965_/B _0902_/B sky130_fd_sc_hd__xor2_1
X_1315_ VGND VPWR _1321_/B _1317_/C _1890_/Q VPWR VGND sky130_fd_sc_hd__xnor2_1
X_1246_ VGND VPWR VGND VPWR _1253_/S _1543_/A _1246_/Y _1245_/Y sky130_fd_sc_hd__a21oi_2
X_1177_ VPWR VGND VGND VPWR _1883_/D _1177_/Y _1221_/B sky130_fd_sc_hd__nand2_1
XFILLER_47_206 VPWR VGND VPWR VGND sky130_fd_sc_hd__decap_3
XFILLER_70_253 VPWR VGND VPWR VGND sky130_fd_sc_hd__decap_3
XFILLER_43_401 VPWR VGND VPWR VGND sky130_fd_sc_hd__decap_3
XPHY_EDGE_ROW_6_Left_78 VPWR VGND VPWR VGND sky130_fd_sc_hd__decap_3
XFILLER_7_27 VGND VPWR VPWR VGND sky130_fd_sc_hd__decap_12
XFILLER_11_375 VGND VPWR VPWR VGND sky130_fd_sc_hd__decap_12
X_1031_ VGND VPWR VGND VPWR _1286_/S0 _1786_/Q _1770_/Q _1286_/S1 _1802_/Q _1818_/Q
+ _1031_/X sky130_fd_sc_hd__mux4_2
X_1100_ VGND VPWR VGND VPWR _1261_/S1 _1753_/Q _1721_/Q _1261_/S0 _1785_/Q _1817_/Q
+ _1100_/X sky130_fd_sc_hd__mux4_2
X_1933_ VPWR VGND _1993_/CLK _2015_/DE _1933_/Q _1933_/D VPWR VGND sky130_fd_sc_hd__edfxtp_1
X_1864_ VPWR VGND _1983_/CLK _1878_/DE _1864_/Q _1864_/D VPWR VGND sky130_fd_sc_hd__edfxtp_1
X_1795_ VPWR VGND _2006_/CLK _1801_/DE _1795_/Q _1795_/D VPWR VGND sky130_fd_sc_hd__edfxtp_1
XFILLER_52_253 VGND VPWR VPWR VGND sky130_fd_sc_hd__decap_12
X_1229_ VGND VPWR VPWR VGND _1853_/D _1481_/A1 _1349_/S _1988_/Q sky130_fd_sc_hd__mux2_1
XFILLER_43_253 VPWR VGND VPWR VGND sky130_fd_sc_hd__decap_3
X_1580_ VGND VPWR VPWR VGND _1821_/D _1593_/B _1857_/Q sky130_fd_sc_hd__and2_0
XFILLER_3_393 VGND VPWR VPWR VGND sky130_fd_sc_hd__decap_12
XFILLER_14_3 VGND VPWR VPWR VGND sky130_fd_sc_hd__decap_12
XFILLER_34_253 VPWR VGND VPWR VGND sky130_fd_sc_hd__decap_8
XFILLER_26_209 VPWR VGND VPWR VGND sky130_fd_sc_hd__decap_8
X_1014_ VGND VPWR VGND VPWR _1286_/S0 _1789_/Q _1773_/Q _1286_/S1 _1805_/Q _1821_/Q
+ _1014_/X sky130_fd_sc_hd__mux4_2
X_1916_ VPWR VGND _1977_/CLK _1917_/DE _1916_/Q _1916_/D VPWR VGND sky130_fd_sc_hd__edfxtp_1
X_1847_ VPWR VGND _1979_/CLK _1667_/Y _1847_/Q _1847_/D VPWR VGND sky130_fd_sc_hd__edfxtp_1
X_1778_ VPWR VGND _1895_/CLK _1790_/DE _1778_/Q _1778_/D VPWR VGND sky130_fd_sc_hd__edfxtp_1
XFILLER_27_57 VPWR VGND VPWR VGND sky130_fd_sc_hd__decap_3
XFILLER_40_267 VPWR VGND VPWR VGND sky130_fd_sc_hd__decap_3
Xinput286 VPWR VGND _1501_/A1 mem_rdata[0] VPWR VGND sky130_fd_sc_hd__buf_4
Xinput297 VPWR VGND _1491_/A1 mem_rdata[5] VPWR VGND sky130_fd_sc_hd__buf_4
XFILLER_63_337 VGND VPWR VPWR VGND sky130_fd_sc_hd__decap_12
XPHY_EDGE_ROW_9_Left_81 VPWR VGND VPWR VGND sky130_fd_sc_hd__decap_3
XFILLER_16_253 VPWR VGND VPWR VGND sky130_fd_sc_hd__decap_8
X_1701_ VPWR VGND _1925_/CLK _1708_/DE _1701_/Q _1701_/D VPWR VGND sky130_fd_sc_hd__edfxtp_1
XFILLER_31_245 VPWR VGND VPWR VGND sky130_fd_sc_hd__decap_8
X_1563_ VPWR VGND VPWR VGND _1562_/Y _1560_/Y _1688_/A _1563_/Y sky130_fd_sc_hd__a21oi_1
X_1494_ VPWR VGND VGND VPWR _1522_/A _1494_/B _1952_/D sky130_fd_sc_hd__nor2_1
X_1632_ VPWR VGND VGND VPWR _1689_/A _1632_/B _1825_/D sky130_fd_sc_hd__nor2_1
XFILLER_66_197 VGND VPWR VPWR VGND sky130_fd_sc_hd__decap_4
XFILLER_62_392 VPWR VGND VPWR VGND sky130_fd_sc_hd__decap_6
XFILLER_13_15 VGND VPWR VPWR VGND sky130_fd_sc_hd__decap_12
XFILLER_49_109 VPWR VGND VPWR VGND sky130_fd_sc_hd__decap_3
XFILLER_1_105 VPWR VGND VPWR VGND sky130_fd_sc_hd__decap_6
XFILLER_1_149 VGND VPWR VPWR VGND sky130_fd_sc_hd__decap_12
XFILLER_45_337 VGND VPWR VPWR VGND sky130_fd_sc_hd__decap_12
XFILLER_70_76 VPWR VGND VPWR VGND sky130_fd_sc_hd__decap_8
XFILLER_13_289 VPWR VGND VPWR VGND sky130_fd_sc_hd__decap_3
Xclkload19 VGND VPWR _1984_/CLK clkload19/X VPWR VGND sky130_fd_sc_hd__clkbuf_4
XFILLER_48_153 VPWR VGND VPWR VGND sky130_fd_sc_hd__decap_8
Xplace145 VPWR VGND place145/X _1246_/Y VPWR VGND sky130_fd_sc_hd__buf_2
XFILLER_63_123 VGND VPWR VPWR VGND sky130_fd_sc_hd__decap_12
XFILLER_48_197 VPWR VGND VPWR VGND sky130_fd_sc_hd__decap_8
XFILLER_36_359 VGND VPWR VPWR VGND sky130_fd_sc_hd__decap_4
X_0994_ VGND VPWR VGND VPWR _0974_/A _1831_/Q _0994_/Y _1832_/Q sky130_fd_sc_hd__o21ai_0
X_1546_ VPWR VGND VGND VPWR _1560_/B _1546_/B _1546_/Y sky130_fd_sc_hd__nor2_1
X_1477_ VPWR VGND VGND VPWR _1961_/Q _1478_/B _1477_/A1 _1584_/S sky130_fd_sc_hd__mux2i_1
X_1615_ VGND VPWR VPWR VGND _1797_/D _1621_/B _1849_/Q sky130_fd_sc_hd__and2_0
XFILLER_39_164 VGND VPWR VPWR VGND sky130_fd_sc_hd__decap_4
XFILLER_27_315 VGND VPWR VPWR VGND sky130_fd_sc_hd__decap_12
XPHY_EDGE_ROW_59_Left_131 VPWR VGND VPWR VGND sky130_fd_sc_hd__decap_3
X_2029_ VPWR VGND _2029_/X _2029_/A VPWR VGND sky130_fd_sc_hd__buf_2
XFILLER_10_248 VGND VPWR VPWR VGND sky130_fd_sc_hd__decap_4
XPHY_EDGE_ROW_68_Left_140 VPWR VGND VPWR VGND sky130_fd_sc_hd__decap_3
XFILLER_49_22 VGND VPWR VPWR VGND sky130_fd_sc_hd__decap_4
X_1331_ VPWR VGND VGND VPWR _1960_/Q _1331_/Y _1331_/B sky130_fd_sc_hd__nand2_1
XFILLER_5_285 VGND VPWR VPWR VGND sky130_fd_sc_hd__decap_12
X_1400_ VGND VPWR VPWR VGND _1746_/D _1402_/B _1846_/Q sky130_fd_sc_hd__and2_0
XFILLER_64_421 VGND VPWR VPWR VGND sky130_fd_sc_hd__decap_4
X_1193_ VGND VPWR _1193_/B _1193_/Y _1193_/A VPWR VGND sky130_fd_sc_hd__xnor2_1
X_1262_ VGND VPWR VPWR VGND _1889_/D _1260_/X _1826_/Q _1261_/X sky130_fd_sc_hd__mux2_1
XFILLER_36_189 VPWR VGND VPWR VGND sky130_fd_sc_hd__decap_6
Xoutput310 VPWR VGND dbg_pc[5] _2022_/X VPWR VGND sky130_fd_sc_hd__buf_4
Xoutput343 VPWR VGND mem_we _1240_/X VPWR VGND sky130_fd_sc_hd__buf_4
Xoutput321 VPWR VGND mem_addr[4] _1249_/X VPWR VGND sky130_fd_sc_hd__buf_4
X_0977_ VPWR VGND VPWR VGND _1878_/Q _0997_/A _0998_/A1 _0977_/Y sky130_fd_sc_hd__a21oi_1
Xoutput332 VPWR VGND mem_wdata[14] _2043_/X VPWR VGND sky130_fd_sc_hd__buf_4
X_1529_ VGND VPWR VPWR VGND _1774_/D _1529_/B _1858_/Q sky130_fd_sc_hd__and2_0
XFILLER_42_115 VPWR VGND VPWR VGND sky130_fd_sc_hd__decap_8
Xclkbuf_3_3__f_clk VGND VPWR VGND VPWR clkbuf_0_clk/X clkbuf_leaf_4_clk/A sky130_fd_sc_hd__clkbuf_16
XPHY_EDGE_ROW_14_Right_14 VPWR VGND VPWR VGND sky130_fd_sc_hd__decap_3
XFILLER_2_277 VGND VPWR VPWR VGND sky130_fd_sc_hd__decap_4
XPHY_EDGE_ROW_23_Right_23 VPWR VGND VPWR VGND sky130_fd_sc_hd__decap_3
XFILLER_46_421 VGND VPWR VPWR VGND sky130_fd_sc_hd__decap_4
X_0900_ VPWR VGND VGND VPWR _0965_/A _0970_/A _1879_/Q _0900_/B sky130_fd_sc_hd__maj3_1
X_1880_ VPWR VGND _1925_/CLK _1925_/DE _1880_/Q _1880_/D VPWR VGND sky130_fd_sc_hd__edfxtp_1
XFILLER_33_137 VPWR VGND VPWR VGND sky130_fd_sc_hd__decap_8
XPHY_EDGE_ROW_32_Right_32 VPWR VGND VPWR VGND sky130_fd_sc_hd__decap_3
X_1314_ VGND VPWR _1314_/B _1317_/B _1892_/Q VPWR VGND sky130_fd_sc_hd__xnor2_1
XPHY_EDGE_ROW_41_Right_41 VPWR VGND VPWR VGND sky130_fd_sc_hd__decap_3
XPHY_EDGE_ROW_22_Left_94 VPWR VGND VPWR VGND sky130_fd_sc_hd__decap_3
XFILLER_64_262 VPWR VGND VPWR VGND sky130_fd_sc_hd__decap_8
X_1245_ VPWR VGND VGND VPWR _1985_/Q _1253_/S _1245_/Y sky130_fd_sc_hd__nor2_1
X_1176_ VGND VPWR VGND VPWR _1134_/Y _1174_/Y _1869_/D _1175_/Y sky130_fd_sc_hd__o21ai_0
XPHY_EDGE_ROW_50_Right_50 VPWR VGND VPWR VGND sky130_fd_sc_hd__decap_3
XFILLER_20_321 VPWR VGND VPWR VGND sky130_fd_sc_hd__decap_8
XFILLER_20_365 VGND VPWR VPWR VGND sky130_fd_sc_hd__decap_4
XFILLER_21_15 VGND VPWR VPWR VGND sky130_fd_sc_hd__decap_12
XFILLER_28_421 VGND VPWR VPWR VGND sky130_fd_sc_hd__decap_4
XFILLER_28_410 VPWR VGND VPWR VGND sky130_fd_sc_hd__decap_8
XFILLER_62_77 VPWR VGND VPWR VGND sky130_fd_sc_hd__decap_6
XFILLER_7_39 VGND VPWR VPWR VGND sky130_fd_sc_hd__decap_12
XFILLER_11_387 VGND VPWR VPWR VGND sky130_fd_sc_hd__decap_4
XFILLER_11_81 VPWR VGND VPWR VGND sky130_fd_sc_hd__decap_6
X_1030_ VGND VPWR VGND VPWR _1286_/S0 _1722_/Q _1706_/Q _1286_/S1 _1738_/Q _1754_/Q
+ _1030_/X sky130_fd_sc_hd__mux4_2
XFILLER_19_410 VGND VPWR VPWR VGND sky130_fd_sc_hd__decap_12
X_1863_ VPWR VGND _1969_/CLK _1878_/DE _1863_/Q _1863_/D VPWR VGND sky130_fd_sc_hd__edfxtp_1
X_1932_ VPWR VGND _1993_/CLK _1932_/DE _1932_/Q _1932_/D VPWR VGND sky130_fd_sc_hd__edfxtp_1
XFILLER_14_181 VPWR VGND VPWR VGND sky130_fd_sc_hd__decap_8
X_1794_ VPWR VGND _2008_/CLK _1801_/DE _1794_/Q _1794_/D VPWR VGND sky130_fd_sc_hd__edfxtp_1
X_1228_ VGND VPWR VPWR VGND _1854_/D _1475_/A1 _1349_/S _1989_/Q sky130_fd_sc_hd__mux2_1
X_1159_ VPWR VGND VPWR VGND _1203_/C _1203_/B _1203_/A _1204_/A sky130_fd_sc_hd__a21oi_1
XFILLER_52_265 VPWR VGND VPWR VGND sky130_fd_sc_hd__decap_8
XFILLER_52_243 VPWR VGND VPWR VGND sky130_fd_sc_hd__decap_8
Xclkbuf_leaf_32_clk clkload4/A clkbuf_3_1__f_clk/X VPWR VGND VGND VPWR sky130_fd_sc_hd__clkbuf_8
XFILLER_16_15 VGND VPWR VPWR VGND sky130_fd_sc_hd__decap_12
XFILLER_32_25 VPWR VGND VPWR VGND sky130_fd_sc_hd__decap_3
XFILLER_57_77 VPWR VGND VPWR VGND sky130_fd_sc_hd__decap_6
Xclkbuf_leaf_23_clk _1925_/CLK clkbuf_3_4__f_clk/X VPWR VGND VGND VPWR sky130_fd_sc_hd__clkbuf_8
XFILLER_11_140 VPWR VGND VPWR VGND sky130_fd_sc_hd__decap_6
XFILLER_3_361 VGND VPWR VPWR VGND sky130_fd_sc_hd__decap_12
X_1013_ VGND VPWR VGND VPWR _1286_/S0 _1725_/Q _1709_/Q _1286_/S1 _1741_/Q _1757_/Q
+ _1013_/X sky130_fd_sc_hd__mux4_2
X_1915_ VPWR VGND _1977_/CLK _1917_/DE _1915_/Q _1915_/D VPWR VGND sky130_fd_sc_hd__edfxtp_1
Xclkbuf_leaf_14_clk _1987_/CLK clkbuf_3_6__f_clk/X VPWR VGND VGND VPWR sky130_fd_sc_hd__clkbuf_8
X_1846_ VPWR VGND _1979_/CLK _1668_/Y _1846_/Q _1846_/D VPWR VGND sky130_fd_sc_hd__edfxtp_1
X_1777_ VPWR VGND _1777_/CLK _1786_/DE _1777_/Q _1777_/D VPWR VGND sky130_fd_sc_hd__edfxtp_1
XPHY_EDGE_ROW_31_Left_103 VPWR VGND VPWR VGND sky130_fd_sc_hd__decap_3
XPHY_EDGE_ROW_4_Right_4 VPWR VGND VPWR VGND sky130_fd_sc_hd__decap_3
XPHY_EDGE_ROW_40_Left_112 VPWR VGND VPWR VGND sky130_fd_sc_hd__decap_3
XFILLER_27_36 VGND VPWR VPWR VGND sky130_fd_sc_hd__decap_12
XFILLER_43_57 VGND VPWR VPWR VGND sky130_fd_sc_hd__decap_4
XFILLER_43_24 VGND VPWR VPWR VGND sky130_fd_sc_hd__decap_4
XFILLER_13_405 VGND VPWR VPWR VGND sky130_fd_sc_hd__decap_12
XFILLER_4_29 VGND VPWR VPWR VGND sky130_fd_sc_hd__decap_12
XFILLER_68_76 VPWR VGND VPWR VGND sky130_fd_sc_hd__decap_8
Xinput287 VPWR VGND _1481_/A1 mem_rdata[10] VPWR VGND sky130_fd_sc_hd__buf_4
XFILLER_71_393 VGND VPWR VPWR VGND sky130_fd_sc_hd__decap_12
XFILLER_71_371 VGND VPWR VPWR VGND sky130_fd_sc_hd__decap_12
Xinput298 VPWR VGND _1489_/A1 mem_rdata[6] VPWR VGND sky130_fd_sc_hd__buf_4
X_1631_ VPWR VGND VGND VPWR _1689_/A _1631_/B _1959_/D sky130_fd_sc_hd__nor2_1
X_1700_ VPWR VGND clkload4/A _1708_/DE _1700_/Q _1700_/D VPWR VGND sky130_fd_sc_hd__edfxtp_1
X_1562_ VPWR VGND VPWR VGND _1606_/C _1561_/Y _1562_/Y _1866_/Q _1608_/A sky130_fd_sc_hd__a22oi_1
X_1493_ VPWR VGND VGND VPWR _1952_/Q _1494_/B _1493_/A1 _1499_/S sky130_fd_sc_hd__mux2i_1
Xclkbuf_leaf_3_clk _1993_/CLK clkbuf_leaf_4_clk/A VPWR VGND VGND VPWR sky130_fd_sc_hd__clkbuf_8
XFILLER_66_187 VGND VPWR VPWR VGND sky130_fd_sc_hd__decap_4
XFILLER_54_305 VPWR VGND VPWR VGND sky130_fd_sc_hd__decap_3
XFILLER_13_27 VGND VPWR VPWR VGND sky130_fd_sc_hd__decap_12
X_1829_ VPWR VGND clkload8/A _1917_/DE _1829_/Q _1829_/D VPWR VGND sky130_fd_sc_hd__edfxtp_1
XFILLER_57_121 VPWR VGND VPWR VGND sky130_fd_sc_hd__decap_3
XFILLER_54_89 VPWR VGND VPWR VGND sky130_fd_sc_hd__decap_8
XFILLER_53_393 VPWR VGND VPWR VGND sky130_fd_sc_hd__decap_6
XFILLER_36_305 VPWR VGND VPWR VGND sky130_fd_sc_hd__decap_3
X_0993_ VPWR VGND VPWR VGND _1875_/Q _0997_/A _0998_/A1 _0993_/X sky130_fd_sc_hd__a21o_1
X_1614_ VGND VPWR VPWR VGND _1798_/D _1621_/B _1850_/Q sky130_fd_sc_hd__and2_0
X_1545_ VPWR VGND VPWR VGND _1606_/D _2026_/A _1608_/A _1546_/B sky130_fd_sc_hd__a21oi_1
X_1476_ VPWR VGND VGND VPWR _1689_/A _1631_/B _1828_/D sky130_fd_sc_hd__nor2_1
X_2028_ VPWR VGND _2028_/X _2028_/A VPWR VGND sky130_fd_sc_hd__buf_2
XFILLER_54_102 VPWR VGND VPWR VGND sky130_fd_sc_hd__decap_8
XFILLER_27_327 VPWR VGND VPWR VGND sky130_fd_sc_hd__decap_8
XFILLER_24_15 VGND VPWR VPWR VGND sky130_fd_sc_hd__decap_12
XFILLER_6_209 VGND VPWR VPWR VGND sky130_fd_sc_hd__decap_4
XFILLER_45_113 VGND VPWR VPWR VGND sky130_fd_sc_hd__decap_12
XFILLER_45_102 VPWR VGND VPWR VGND sky130_fd_sc_hd__decap_6
XFILLER_18_305 VPWR VGND VPWR VGND sky130_fd_sc_hd__decap_3
XFILLER_18_338 VGND VPWR VPWR VGND sky130_fd_sc_hd__decap_12
X_1330_ VGND VPWR VPWR VGND _1994_/D _0974_/A _1353_/D _1538_/B sky130_fd_sc_hd__mux2_1
XFILLER_5_297 VGND VPWR VPWR VGND sky130_fd_sc_hd__decap_12
X_1261_ VGND VPWR VGND VPWR _1261_/S0 _1790_/Q _1726_/Q _1261_/S1 _1758_/Q _1822_/Q
+ _1261_/X sky130_fd_sc_hd__mux4_2
XFILLER_64_400 VGND VPWR VPWR VGND sky130_fd_sc_hd__decap_12
X_1192_ VGND VPWR VGND VPWR _1187_/Y _1190_/Y _1866_/D _1191_/Y sky130_fd_sc_hd__o21ai_0
X_0976_ VGND VPWR _0976_/B _0976_/Y _0976_/A VPWR VGND sky130_fd_sc_hd__xnor2_1
Xoutput322 VPWR VGND mem_addr[5] _1248_/X VPWR VGND sky130_fd_sc_hd__buf_4
Xoutput311 VPWR VGND dbg_pc[6] _2023_/X VPWR VGND sky130_fd_sc_hd__buf_4
Xoutput333 VPWR VGND mem_wdata[15] _2044_/X VPWR VGND sky130_fd_sc_hd__buf_4
X_1459_ VPWR VGND VGND VPWR _1553_/B _1565_/A _1459_/B sky130_fd_sc_hd__or2_1
XFILLER_27_113 VGND VPWR VPWR VGND sky130_fd_sc_hd__decap_12
X_1528_ VGND VPWR VPWR VGND _1758_/D _1528_/B _1858_/Q sky130_fd_sc_hd__and2_0
XFILLER_19_15 VGND VPWR VPWR VGND sky130_fd_sc_hd__decap_12
XFILLER_51_24 VPWR VGND VPWR VGND sky130_fd_sc_hd__decap_8
XFILLER_4_3 VGND VPWR VPWR VGND sky130_fd_sc_hd__decap_12
X_1244_ VGND VPWR VPWR VGND _1244_/X _2025_/A _1253_/S _1986_/Q sky130_fd_sc_hd__mux2_1
XFILLER_56_208 VGND VPWR VPWR VGND sky130_fd_sc_hd__decap_4
X_1313_ VGND VPWR VGND VPWR _1313_/B _1313_/D _1324_/A _1313_/A _1313_/C sky130_fd_sc_hd__nor4_2
XFILLER_37_3 VGND VPWR VPWR VGND sky130_fd_sc_hd__decap_12
XFILLER_64_285 VGND VPWR VPWR VGND sky130_fd_sc_hd__decap_12
X_1175_ VGND VPWR VGND VPWR _1207_/B _1958_/Q _1175_/Y _1339_/A1 sky130_fd_sc_hd__o21ai_0
X_0959_ VPWR VGND VGND VPWR _1367_/A1 _0954_/Y _1986_/D _0958_/Y _0956_/Y _0957_/Y
+ sky130_fd_sc_hd__o221ai_1
XFILLER_20_333 VPWR VGND VPWR VGND sky130_fd_sc_hd__decap_6
XFILLER_7_337 VGND VPWR VPWR VGND sky130_fd_sc_hd__decap_12
XFILLER_11_93 VGND VPWR VPWR VGND sky130_fd_sc_hd__decap_12
XFILLER_19_422 VGND VPWR VPWR VGND sky130_fd_sc_hd__decap_4
XFILLER_61_244 VGND VPWR VPWR VGND sky130_fd_sc_hd__decap_4
XFILLER_21_108 VGND VPWR VPWR VGND sky130_fd_sc_hd__decap_4
X_1862_ VPWR VGND _1984_/CLK _1878_/DE _1862_/Q _1862_/D VPWR VGND sky130_fd_sc_hd__edfxtp_1
X_1931_ VPWR VGND _1993_/CLK _2015_/DE _1931_/Q _1931_/D VPWR VGND sky130_fd_sc_hd__edfxtp_1
X_1793_ VPWR VGND _2007_/CLK _1801_/DE _1793_/Q _1793_/D VPWR VGND sky130_fd_sc_hd__edfxtp_1
X_1158_ VGND VPWR _1209_/B _1210_/A _1203_/C _1939_/Q VPWR VGND sky130_fd_sc_hd__o21ai_1
X_1227_ VGND VPWR VPWR VGND _1855_/D _1479_/A1 _1349_/S _1990_/Q sky130_fd_sc_hd__mux2_1
XFILLER_40_417 VPWR VGND VPWR VGND sky130_fd_sc_hd__decap_3
XFILLER_20_141 VGND VPWR VPWR VGND sky130_fd_sc_hd__decap_4
X_1089_ VGND VPWR VPWR VGND _1888_/D _1087_/X _1826_/Q _1088_/X sky130_fd_sc_hd__mux2_1
XFILLER_57_89 VPWR VGND VPWR VGND sky130_fd_sc_hd__decap_6
XFILLER_11_152 VGND VPWR VPWR VGND sky130_fd_sc_hd__decap_12
XFILLER_3_373 VGND VPWR VPWR VGND sky130_fd_sc_hd__decap_12
X_1012_ VGND VPWR VPWR VGND _1006_/Y _1133_/A _1357_/A _1012_/Y _1011_/Y sky130_fd_sc_hd__a31oi_1
X_1914_ _1914_/Q clkload8/A _1914_/D VPWR VGND VPWR VGND sky130_fd_sc_hd__dfxtp_1
XFILLER_34_244 VPWR VGND VPWR VGND sky130_fd_sc_hd__decap_8
X_1845_ VPWR VGND _1979_/CLK _1669_/Y _1845_/Q _1845_/D VPWR VGND sky130_fd_sc_hd__edfxtp_1
X_1776_ VPWR VGND _1895_/CLK _1790_/DE _1776_/Q _1776_/D VPWR VGND sky130_fd_sc_hd__edfxtp_1
XFILLER_65_380 VPWR VGND VPWR VGND sky130_fd_sc_hd__decap_6
XFILLER_43_36 VPWR VGND VPWR VGND sky130_fd_sc_hd__decap_8
XFILLER_13_417 VPWR VGND VPWR VGND sky130_fd_sc_hd__decap_8
XFILLER_25_277 VPWR VGND VPWR VGND sky130_fd_sc_hd__decap_3
XFILLER_0_321 VGND VPWR VPWR VGND sky130_fd_sc_hd__decap_12
XFILLER_63_328 VPWR VGND VPWR VGND sky130_fd_sc_hd__decap_3
XFILLER_48_336 VPWR VGND VPWR VGND sky130_fd_sc_hd__decap_3
Xinput288 VPWR VGND _1475_/A1 mem_rdata[11] VPWR VGND sky130_fd_sc_hd__buf_4
Xinput299 VPWR VGND _1487_/A1 mem_rdata[7] VPWR VGND sky130_fd_sc_hd__buf_4
XFILLER_0_365 VGND VPWR VPWR VGND sky130_fd_sc_hd__decap_12
XFILLER_71_383 VPWR VGND VPWR VGND sky130_fd_sc_hd__decap_8
X_1630_ VGND VPWR VPWR VGND _1781_/D _1630_/B _1849_/Q sky130_fd_sc_hd__and2_0
XFILLER_8_421 VGND VPWR VPWR VGND sky130_fd_sc_hd__decap_4
X_1492_ VPWR VGND VGND VPWR _1688_/A _1492_/B _1953_/D sky130_fd_sc_hd__nor2_1
X_1561_ VGND VPWR _1565_/B _1561_/Y _2024_/A VPWR VGND sky130_fd_sc_hd__xnor2_1
XFILLER_3_181 VGND VPWR VPWR VGND sky130_fd_sc_hd__decap_12
XFILLER_66_133 VPWR VGND VPWR VGND sky130_fd_sc_hd__decap_6
X_2044_ VPWR VGND _2044_/X _2044_/A VPWR VGND sky130_fd_sc_hd__buf_2
XFILLER_13_39 VGND VPWR VPWR VGND sky130_fd_sc_hd__decap_12
Xhold410 _1460_/A _2019_/A VPWR VGND VGND VPWR sky130_fd_sc_hd__dlygate4sd3_1
X_1828_ _1828_/Q _1963_/CLK _1828_/D VPWR VGND VPWR VGND sky130_fd_sc_hd__dfxtp_1
X_1759_ VPWR VGND _2001_/CLK _1774_/DE _1759_/Q _1759_/D VPWR VGND sky130_fd_sc_hd__edfxtp_1
XFILLER_44_372 VPWR VGND VPWR VGND sky130_fd_sc_hd__decap_8
X_0992_ VPWR VGND VGND VPWR _0992_/A _0992_/B _0992_/Y sky130_fd_sc_hd__nor2_1
XFILLER_67_3 VGND VPWR VPWR VGND sky130_fd_sc_hd__decap_12
X_1544_ VPWR VGND _1606_/D _1555_/B _2025_/A VPWR VGND sky130_fd_sc_hd__and2_1
X_1613_ VGND VPWR VPWR VGND _1799_/D _1613_/B _1851_/Q sky130_fd_sc_hd__and2_0
XFILLER_5_51 VGND VPWR VPWR VGND sky130_fd_sc_hd__decap_4
X_1475_ VPWR VGND VGND VPWR _1959_/Q _1631_/B _1475_/A1 _1584_/S sky130_fd_sc_hd__mux2i_1
XFILLER_5_95 VGND VPWR VPWR VGND sky130_fd_sc_hd__decap_12
X_2027_ VPWR VGND _2027_/X _2027_/A VPWR VGND sky130_fd_sc_hd__buf_2
XFILLER_42_309 VGND VPWR VPWR VGND sky130_fd_sc_hd__decap_4
XFILLER_49_57 VPWR VGND VPWR VGND sky130_fd_sc_hd__decap_6
XFILLER_45_125 VPWR VGND VPWR VGND sky130_fd_sc_hd__decap_3
XFILLER_18_317 VPWR VGND VPWR VGND sky130_fd_sc_hd__decap_3
XFILLER_53_191 VGND VPWR VPWR VGND sky130_fd_sc_hd__decap_12
XFILLER_41_342 VGND VPWR VPWR VGND sky130_fd_sc_hd__decap_4
XFILLER_5_276 VGND VPWR VPWR VGND sky130_fd_sc_hd__decap_4
XFILLER_5_243 VPWR VGND VPWR VGND sky130_fd_sc_hd__decap_8
X_1191_ VGND VPWR VGND VPWR _1207_/B _1307_/A _1191_/Y _1339_/A1 sky130_fd_sc_hd__o21ai_0
X_1260_ VGND VPWR VGND VPWR _1261_/S0 _1774_/Q _1710_/Q _1261_/S1 _1742_/Q _1806_/Q
+ _1260_/X sky130_fd_sc_hd__mux4_2
XFILLER_64_412 VPWR VGND VPWR VGND sky130_fd_sc_hd__decap_8
XFILLER_36_136 VGND VPWR VPWR VGND sky130_fd_sc_hd__decap_4
XFILLER_36_125 VPWR VGND VPWR VGND sky130_fd_sc_hd__decap_6
X_0975_ VPWR VGND VGND VPWR _0992_/A _0970_/Y _1983_/D _0974_/Y _0972_/Y _0973_/Y
+ sky130_fd_sc_hd__o221ai_1
XFILLER_32_353 VPWR VGND VPWR VGND sky130_fd_sc_hd__decap_3
Xoutput312 VPWR VGND dbg_pc[7] _2024_/X VPWR VGND sky130_fd_sc_hd__buf_4
Xoutput323 VPWR VGND mem_addr[6] _1247_/X VPWR VGND sky130_fd_sc_hd__buf_4
Xoutput334 VPWR VGND mem_wdata[1] _2030_/X VPWR VGND sky130_fd_sc_hd__buf_4
XFILLER_10_29 VGND VPWR VPWR VGND sky130_fd_sc_hd__decap_12
X_1527_ VGND VPWR VPWR VGND _1742_/D _1527_/B _1858_/Q sky130_fd_sc_hd__and2_0
X_1458_ VPWR VGND VGND VPWR _1565_/A _1459_/B _1560_/B sky130_fd_sc_hd__nor2_1
XFILLER_27_125 VGND VPWR VPWR VGND sky130_fd_sc_hd__decap_12
X_1389_ VGND VPWR VPWR VGND _1757_/D _1528_/B _1857_/Q sky130_fd_sc_hd__and2_0
XFILLER_35_37 VGND VPWR VPWR VGND sky130_fd_sc_hd__decap_12
XFILLER_27_169 VGND VPWR VPWR VGND sky130_fd_sc_hd__decap_12
XFILLER_23_331 VGND VPWR VPWR VGND sky130_fd_sc_hd__decap_4
XFILLER_41_161 VPWR VGND VPWR VGND sky130_fd_sc_hd__decap_6
XFILLER_14_342 VGND VPWR VPWR VGND sky130_fd_sc_hd__decap_12
XFILLER_25_92 VPWR VGND VPWR VGND sky130_fd_sc_hd__decap_6
X_1243_ VGND VPWR VPWR VGND _1243_/X _2026_/A _1350_/S _1987_/Q sky130_fd_sc_hd__mux2_1
X_1174_ VPWR VGND VPWR VGND _1343_/B _1136_/Y _1173_/Y _1174_/Y sky130_fd_sc_hd__a21oi_1
X_1312_ VGND VPWR _1314_/B _1313_/D _1917_/Q VPWR VGND sky130_fd_sc_hd__xnor2_1
XFILLER_49_250 VGND VPWR VPWR VGND sky130_fd_sc_hd__decap_12
XFILLER_2_85 VGND VPWR VPWR VGND sky130_fd_sc_hd__decap_12
XFILLER_2_41 VGND VPWR VPWR VGND sky130_fd_sc_hd__decap_12
XFILLER_64_297 VPWR VGND VPWR VGND sky130_fd_sc_hd__decap_8
XFILLER_20_301 VPWR VGND VPWR VGND sky130_fd_sc_hd__decap_6
X_0958_ VPWR VGND VGND VPWR _0974_/A _0958_/Y _0958_/B sky130_fd_sc_hd__nand2_1
X_0889_ VPWR VGND VGND VPWR _1874_/Q _1919_/Q _0892_/C sky130_fd_sc_hd__nand2b_1
XFILLER_70_201 VPWR VGND VPWR VGND sky130_fd_sc_hd__decap_3
XFILLER_7_305 VGND VPWR VPWR VGND sky130_fd_sc_hd__decap_12
XFILLER_7_349 VGND VPWR VPWR VGND sky130_fd_sc_hd__decap_12
XFILLER_46_253 VPWR VGND VPWR VGND sky130_fd_sc_hd__decap_6
X_1930_ VPWR VGND _1993_/CLK _1932_/DE _1930_/Q _1930_/D VPWR VGND sky130_fd_sc_hd__edfxtp_1
X_1861_ VPWR VGND _1984_/CLK _1878_/DE _1861_/Q _1861_/D VPWR VGND sky130_fd_sc_hd__edfxtp_1
X_1792_ VPWR VGND _2008_/CLK _1801_/DE _1792_/Q _1792_/D VPWR VGND sky130_fd_sc_hd__edfxtp_1
XFILLER_69_323 VGND VPWR VPWR VGND sky130_fd_sc_hd__decap_12
X_1157_ VPWR VGND VGND VPWR _1210_/A _1213_/A _1938_/Q _1157_/B sky130_fd_sc_hd__maj3_1
XFILLER_52_223 VGND VPWR VPWR VGND sky130_fd_sc_hd__decap_12
X_1226_ VGND VPWR VPWR VGND _1856_/D _1477_/A1 _1238_/S hold413/X sky130_fd_sc_hd__mux2_1
X_1088_ VGND VPWR VGND VPWR _1261_/S1 _1757_/Q _1725_/Q _1261_/S0 _1789_/Q _1821_/Q
+ _1088_/X sky130_fd_sc_hd__mux4_2
XFILLER_20_186 VPWR VGND VPWR VGND sky130_fd_sc_hd__decap_8
XFILLER_20_197 VPWR VGND VPWR VGND sky130_fd_sc_hd__decap_6
XFILLER_57_57 VGND VPWR VPWR VGND sky130_fd_sc_hd__decap_4
XFILLER_11_164 VGND VPWR VPWR VGND sky130_fd_sc_hd__decap_4
XFILLER_3_385 VPWR VGND VPWR VGND sky130_fd_sc_hd__decap_6
X_1011_ VPWR VGND VGND VPWR _1360_/A _1011_/Y sky130_fd_sc_hd__inv_1
XFILLER_19_264 VGND VPWR VPWR VGND sky130_fd_sc_hd__decap_12
X_1913_ VPWR VGND clkload8/A _1672_/Y _1913_/Q _1913_/D VPWR VGND sky130_fd_sc_hd__edfxtp_1
XFILLER_34_267 VPWR VGND VPWR VGND sky130_fd_sc_hd__decap_6
X_1844_ VPWR VGND _2007_/CLK _1670_/Y _1844_/Q _1844_/D VPWR VGND sky130_fd_sc_hd__edfxtp_1
X_1775_ VPWR VGND _1807_/CLK _1790_/DE _1775_/Q _1775_/D VPWR VGND sky130_fd_sc_hd__edfxtp_1
XFILLER_69_175 VPWR VGND VPWR VGND sky130_fd_sc_hd__decap_6
X_1209_ VGND VPWR VPWR VGND _1939_/Q _1210_/B _1209_/B sky130_fd_sc_hd__xor2_1
XFILLER_25_212 VPWR VGND VPWR VGND sky130_fd_sc_hd__decap_6
XFILLER_40_259 VPWR VGND VPWR VGND sky130_fd_sc_hd__decap_8
XFILLER_0_355 VPWR VGND VPWR VGND sky130_fd_sc_hd__decap_8
XFILLER_0_333 VPWR VGND VPWR VGND sky130_fd_sc_hd__decap_3
Xinput289 VPWR VGND _1479_/A1 mem_rdata[12] VPWR VGND sky130_fd_sc_hd__buf_4
XFILLER_0_377 VGND VPWR VPWR VGND sky130_fd_sc_hd__decap_12
XFILLER_31_215 VGND VPWR VPWR VGND sky130_fd_sc_hd__decap_4
X_1560_ VPWR VGND VGND VPWR _1560_/A _1560_/Y _1560_/B sky130_fd_sc_hd__nand2_1
X_1491_ VPWR VGND VGND VPWR _1953_/Q _1492_/B _1491_/A1 _1565_/A sky130_fd_sc_hd__mux2i_1
XFILLER_39_337 VPWR VGND VPWR VGND sky130_fd_sc_hd__decap_8
XFILLER_3_193 VGND VPWR VPWR VGND sky130_fd_sc_hd__decap_12
XFILLER_12_3 VGND VPWR VPWR VGND sky130_fd_sc_hd__decap_12
X_2043_ VPWR VGND _2043_/X _2043_/A VPWR VGND sky130_fd_sc_hd__buf_2
X_1827_ _1827_/Q _1963_/CLK _1827_/D VPWR VGND VPWR VGND sky130_fd_sc_hd__dfxtp_1
Xhold411 _1967_/D _1465_/Y VPWR VGND VGND VPWR sky130_fd_sc_hd__dlygate4sd3_1
Xhold400 _1892_/D _1873_/Q VPWR VGND VGND VPWR sky130_fd_sc_hd__dlygate4sd3_1
X_1689_ VPWR VGND VGND VPWR _1689_/A _1689_/B _1827_/D sky130_fd_sc_hd__nor2_1
X_1758_ VPWR VGND clkload3/A _1758_/DE _1758_/Q _1758_/D VPWR VGND sky130_fd_sc_hd__edfxtp_1
XFILLER_45_318 VPWR VGND VPWR VGND sky130_fd_sc_hd__decap_3
XFILLER_48_123 VGND VPWR VPWR VGND sky130_fd_sc_hd__decap_12
XFILLER_0_141 VGND VPWR VPWR VGND sky130_fd_sc_hd__decap_12
X_0991_ VPWR VGND VGND VPWR _0991_/A _0991_/Y _0991_/B sky130_fd_sc_hd__nand2_1
XFILLER_8_241 VPWR VGND VPWR VGND sky130_fd_sc_hd__decap_8
X_1543_ VPWR VGND VGND VPWR _1543_/A _1565_/B _1555_/B sky130_fd_sc_hd__nor2_1
X_1474_ VPWR VGND VGND VPWR _1673_/A _1474_/B _1962_/D sky130_fd_sc_hd__nor2_1
X_1612_ VGND VPWR VPWR VGND _1800_/D _1621_/B _1852_/Q sky130_fd_sc_hd__and2_0
XFILLER_39_189 VPWR VGND VPWR VGND sky130_fd_sc_hd__decap_3
X_2026_ VPWR VGND _2026_/X _2026_/A VPWR VGND sky130_fd_sc_hd__buf_2
XFILLER_50_365 VGND VPWR VPWR VGND sky130_fd_sc_hd__decap_12
XFILLER_50_343 VGND VPWR VPWR VGND sky130_fd_sc_hd__decap_12
XPHY_EDGE_ROW_28_Left_100 VPWR VGND VPWR VGND sky130_fd_sc_hd__decap_3
XFILLER_58_421 VGND VPWR VPWR VGND sky130_fd_sc_hd__decap_4
XFILLER_58_410 VPWR VGND VPWR VGND sky130_fd_sc_hd__decap_8
XFILLER_65_57 VPWR VGND VPWR VGND sky130_fd_sc_hd__decap_3
XFILLER_45_137 VGND VPWR VPWR VGND sky130_fd_sc_hd__decap_12
X_1190_ VPWR VGND VPWR VGND _1188_/X _1162_/Y _1189_/Y _1190_/Y sky130_fd_sc_hd__a21oi_1
XFILLER_39_80 VGND VPWR VPWR VGND sky130_fd_sc_hd__decap_4
XFILLER_51_118 VGND VPWR VPWR VGND sky130_fd_sc_hd__decap_12
XFILLER_51_107 VGND VPWR VPWR VGND sky130_fd_sc_hd__decap_4
X_0974_ VPWR VGND VGND VPWR _0974_/A _0974_/Y _0974_/B sky130_fd_sc_hd__nand2_1
Xoutput324 VPWR VGND mem_addr[7] place145/X VPWR VGND sky130_fd_sc_hd__buf_4
Xoutput313 VPWR VGND dbg_pc[8] _2025_/X VPWR VGND sky130_fd_sc_hd__buf_4
X_1457_ VGND VPWR VPWR VGND _1456_/X _1998_/Q _1459_/B _1829_/Q _1935_/Q sky130_fd_sc_hd__o211a_2
Xoutput335 VPWR VGND mem_wdata[2] _2031_/X VPWR VGND sky130_fd_sc_hd__buf_4
X_1526_ VGND VPWR VPWR VGND _1726_/D _1526_/B _1858_/Q sky130_fd_sc_hd__and2_0
XFILLER_55_402 VGND VPWR VPWR VGND sky130_fd_sc_hd__decap_12
X_1388_ VGND VPWR VPWR VGND _1759_/D _1529_/B _1843_/Q sky130_fd_sc_hd__and2_0
XFILLER_19_39 VGND VPWR VPWR VGND sky130_fd_sc_hd__decap_12
X_2009_ VPWR VGND _2009_/CLK _2015_/DE _2009_/Q _2009_/D VPWR VGND sky130_fd_sc_hd__edfxtp_1
XFILLER_23_365 VGND VPWR VPWR VGND sky130_fd_sc_hd__decap_12
XFILLER_46_413 VPWR VGND VPWR VGND sky130_fd_sc_hd__decap_6
XFILLER_14_321 VPWR VGND VPWR VGND sky130_fd_sc_hd__decap_3
XFILLER_14_354 VPWR VGND VPWR VGND sky130_fd_sc_hd__decap_8
XFILLER_14_365 VPWR VGND VPWR VGND sky130_fd_sc_hd__decap_8
XFILLER_18_137 VPWR VGND VPWR VGND sky130_fd_sc_hd__decap_3
X_1311_ VPWR VGND VGND VPWR _1956_/Q _1314_/B _1311_/B sky130_fd_sc_hd__nand2_1
X_1242_ VGND VPWR VPWR VGND _1242_/X _2027_/A _1350_/S _1988_/Q sky130_fd_sc_hd__mux2_1
X_1173_ VGND VPWR VGND VPWR _1339_/A1 _1136_/Y _1173_/Y _1343_/B sky130_fd_sc_hd__o21ai_0
XFILLER_52_405 VGND VPWR VPWR VGND sky130_fd_sc_hd__decap_12
XFILLER_49_262 VGND VPWR VPWR VGND sky130_fd_sc_hd__decap_12
XFILLER_2_97 VGND VPWR VPWR VGND sky130_fd_sc_hd__decap_12
XFILLER_2_53 VGND VPWR VPWR VGND sky130_fd_sc_hd__decap_12
XPHY_EDGE_ROW_10_Right_10 VPWR VGND VPWR VGND sky130_fd_sc_hd__decap_3
XFILLER_17_181 VGND VPWR VPWR VGND sky130_fd_sc_hd__decap_12
XFILLER_20_357 VPWR VGND VPWR VGND sky130_fd_sc_hd__decap_6
X_0957_ VPWR VGND VGND VPWR _1839_/Q _0957_/B _0957_/Y sky130_fd_sc_hd__nor2_1
X_0888_ VPWR VGND VGND VPWR _1919_/Q _1874_/Q _0991_/A sky130_fd_sc_hd__nor2b_1
X_1509_ VPWR VGND VGND VPWR _1943_/Q _1606_/C _1509_/Y sky130_fd_sc_hd__nor2_1
XFILLER_70_246 VPWR VGND VPWR VGND sky130_fd_sc_hd__decap_6
XFILLER_55_287 VGND VPWR VPWR VGND sky130_fd_sc_hd__decap_12
XFILLER_55_232 VPWR VGND VPWR VGND sky130_fd_sc_hd__decap_3
XFILLER_55_210 VPWR VGND VPWR VGND sky130_fd_sc_hd__decap_6
Xclkbuf_leaf_35_clk clkload6/A clkbuf_3_1__f_clk/X VPWR VGND VGND VPWR sky130_fd_sc_hd__clkbuf_8
XFILLER_23_140 VPWR VGND VPWR VGND sky130_fd_sc_hd__decap_8
XFILLER_7_317 VGND VPWR VPWR VGND sky130_fd_sc_hd__decap_12
X_1860_ VPWR VGND _1984_/CLK _1878_/DE _1860_/Q _1860_/D VPWR VGND sky130_fd_sc_hd__edfxtp_1
Xclkbuf_leaf_26_clk _2007_/CLK clkbuf_3_5__f_clk/X VPWR VGND VGND VPWR sky130_fd_sc_hd__clkbuf_8
XPHY_EDGE_ROW_26_Left_98 VPWR VGND VPWR VGND sky130_fd_sc_hd__decap_3
X_1791_ VPWR VGND _1807_/CLK _1801_/DE _1791_/Q _1791_/D VPWR VGND sky130_fd_sc_hd__edfxtp_1
Xclkbuf_leaf_17_clk _1984_/CLK clkbuf_3_6__f_clk/X VPWR VGND VGND VPWR sky130_fd_sc_hd__clkbuf_8
X_1156_ VGND VPWR VPWR VGND _1938_/Q _1213_/B _1157_/B sky130_fd_sc_hd__xor2_1
X_1225_ VGND VPWR VPWR VGND _1857_/D _1473_/A1 _1349_/S _1992_/Q sky130_fd_sc_hd__mux2_1
XFILLER_16_29 VPWR VGND VPWR VGND sky130_fd_sc_hd__decap_8
X_1087_ VGND VPWR VGND VPWR _1261_/S1 _1741_/Q _1709_/Q _1261_/S0 _1773_/Q _1805_/Q
+ _1087_/X sky130_fd_sc_hd__mux4_2
X_1989_ VPWR VGND _1997_/CLK _1677_/Y _1989_/Q _1989_/D VPWR VGND sky130_fd_sc_hd__edfxtp_1
XFILLER_20_121 VGND VPWR VPWR VGND sky130_fd_sc_hd__decap_12
XFILLER_4_309 VGND VPWR VPWR VGND sky130_fd_sc_hd__decap_12
XFILLER_57_47 VPWR VGND VPWR VGND sky130_fd_sc_hd__decap_8
X_1010_ VPWR VGND VGND VPWR _1357_/B _1355_/A _1360_/A sky130_fd_sc_hd__nor2_1
XFILLER_19_221 VPWR VGND VPWR VGND sky130_fd_sc_hd__decap_3
XFILLER_19_276 VGND VPWR VPWR VGND sky130_fd_sc_hd__decap_4
X_1843_ VPWR VGND _1988_/CLK _1671_/Y _1843_/Q _1843_/D VPWR VGND sky130_fd_sc_hd__edfxtp_1
X_1912_ VPWR VGND clkload8/A _1917_/DE _1912_/Q _1912_/D VPWR VGND sky130_fd_sc_hd__edfxtp_1
XFILLER_8_41 VGND VPWR VPWR VGND sky130_fd_sc_hd__decap_12
Xclkbuf_leaf_6_clk _1963_/CLK clkbuf_leaf_9_clk/A VPWR VGND VGND VPWR sky130_fd_sc_hd__clkbuf_8
X_1774_ VPWR VGND _2016_/CLK _1774_/DE _1774_/Q _1774_/D VPWR VGND sky130_fd_sc_hd__edfxtp_1
XFILLER_69_198 VPWR VGND VPWR VGND sky130_fd_sc_hd__decap_8
XFILLER_69_165 VPWR VGND VPWR VGND sky130_fd_sc_hd__decap_3
X_1208_ VPWR VGND VPWR VGND _1206_/Y _1205_/Y _1207_/Y _1863_/D sky130_fd_sc_hd__a21oi_1
XFILLER_65_393 VGND VPWR VPWR VGND sky130_fd_sc_hd__decap_4
X_1139_ VGND VPWR VPWR VGND _1165_/A _1140_/B _1944_/Q sky130_fd_sc_hd__and2_0
XFILLER_43_49 VPWR VGND VPWR VGND sky130_fd_sc_hd__decap_6
XFILLER_0_389 VPWR VGND VPWR VGND sky130_fd_sc_hd__decap_3
XFILLER_8_401 VGND VPWR VPWR VGND sky130_fd_sc_hd__decap_12
X_1490_ VPWR VGND VGND VPWR _1693_/A _1693_/B _1954_/D sky130_fd_sc_hd__nor2_1
XFILLER_3_161 VPWR VGND VPWR VGND sky130_fd_sc_hd__decap_6
X_2042_ VPWR VGND _2042_/X _2042_/A VPWR VGND sky130_fd_sc_hd__buf_2
XFILLER_47_393 VGND VPWR VPWR VGND sky130_fd_sc_hd__decap_12
XPHY_EDGE_ROW_8_Right_8 VPWR VGND VPWR VGND sky130_fd_sc_hd__decap_3
Xhold401 _1871_/D _1915_/Q VPWR VGND VGND VPWR sky130_fd_sc_hd__dlygate4sd3_1
X_1826_ _1826_/Q _2000_/CLK _1826_/D VPWR VGND VPWR VGND sky130_fd_sc_hd__dfxtp_2
X_1688_ VPWR VGND VGND VPWR _1688_/A _1688_/Y sky130_fd_sc_hd__inv_1
Xhold412 hold412/X _1865_/Q VPWR VGND VGND VPWR sky130_fd_sc_hd__dlygate4sd3_1
XPHY_EDGE_ROW_39_Right_39 VPWR VGND VPWR VGND sky130_fd_sc_hd__decap_3
X_1757_ VPWR VGND clkload3/A _1758_/DE _1757_/Q _1757_/D VPWR VGND sky130_fd_sc_hd__edfxtp_1
XFILLER_57_146 VGND VPWR VPWR VGND sky130_fd_sc_hd__decap_12
XFILLER_57_113 VPWR VGND VPWR VGND sky130_fd_sc_hd__decap_8
XFILLER_38_371 VGND VPWR VPWR VGND sky130_fd_sc_hd__decap_12
XPHY_EDGE_ROW_13_Left_85 VPWR VGND VPWR VGND sky130_fd_sc_hd__decap_3
XPHY_EDGE_ROW_48_Right_48 VPWR VGND VPWR VGND sky130_fd_sc_hd__decap_3
XFILLER_21_271 VPWR VGND VPWR VGND sky130_fd_sc_hd__decap_8
XPHY_EDGE_ROW_57_Right_57 VPWR VGND VPWR VGND sky130_fd_sc_hd__decap_3
XFILLER_48_135 VGND VPWR VPWR VGND sky130_fd_sc_hd__decap_4
XFILLER_0_153 VGND VPWR VPWR VGND sky130_fd_sc_hd__decap_12
XFILLER_0_197 VGND VPWR VPWR VGND sky130_fd_sc_hd__decap_12
XPHY_EDGE_ROW_66_Right_66 VPWR VGND VPWR VGND sky130_fd_sc_hd__decap_3
XFILLER_48_179 VPWR VGND VPWR VGND sky130_fd_sc_hd__decap_8
X_1611_ VPWR VGND VGND VPWR hold393/X _1679_/A _1977_/D sky130_fd_sc_hd__nor2b_1
X_0990_ VGND VPWR VGND VPWR _0989_/X _0992_/A _1980_/D _0986_/Y sky130_fd_sc_hd__o21ai_0
X_1542_ VPWR VGND VGND VPWR _2022_/A _2023_/A _1565_/B _1542_/C sky130_fd_sc_hd__nand3_1
X_1473_ VPWR VGND VGND VPWR _1353_/B _1474_/B _1473_/A1 _1584_/S sky130_fd_sc_hd__mux2i_1
X_2025_ VPWR VGND _2025_/X _2025_/A VPWR VGND sky130_fd_sc_hd__buf_2
XFILLER_39_113 VPWR VGND VPWR VGND sky130_fd_sc_hd__decap_6
XFILLER_35_330 VPWR VGND VPWR VGND sky130_fd_sc_hd__decap_6
XFILLER_50_377 VPWR VGND VPWR VGND sky130_fd_sc_hd__decap_3
XFILLER_50_355 VPWR VGND VPWR VGND sky130_fd_sc_hd__decap_8
X_1809_ VPWR VGND _2008_/CLK _1817_/DE _1809_/Q _1809_/D VPWR VGND sky130_fd_sc_hd__edfxtp_1
XFILLER_65_47 VPWR VGND VPWR VGND sky130_fd_sc_hd__decap_6
XFILLER_45_149 VPWR VGND VPWR VGND sky130_fd_sc_hd__decap_8
Xoutput303 VPWR VGND dbg_pc[0] _2017_/X VPWR VGND sky130_fd_sc_hd__buf_4
Xoutput325 VPWR VGND mem_addr[8] _1244_/X VPWR VGND sky130_fd_sc_hd__buf_4
Xoutput314 VPWR VGND dbg_pc[9] _2026_/X VPWR VGND sky130_fd_sc_hd__buf_4
X_0973_ VPWR VGND VGND VPWR _1836_/Q _0973_/B _0973_/Y sky130_fd_sc_hd__nor2_1
X_1456_ VGND VPWR VPWR VGND _1456_/X _1999_/Q _1456_/S _2000_/Q sky130_fd_sc_hd__mux2_1
X_1387_ VGND VPWR VPWR VGND _1760_/D _1529_/B _1844_/Q sky130_fd_sc_hd__and2_0
Xoutput336 VPWR VGND mem_wdata[3] _2032_/X VPWR VGND sky130_fd_sc_hd__buf_4
X_1525_ VGND VPWR VPWR VGND _1710_/D _1525_/B _1858_/Q sky130_fd_sc_hd__and2_0
XFILLER_70_406 VGND VPWR VPWR VGND sky130_fd_sc_hd__decap_12
XFILLER_55_414 VPWR VGND VPWR VGND sky130_fd_sc_hd__decap_6
X_2008_ VPWR VGND _2008_/CLK _2008_/DE _2008_/Q _2008_/D VPWR VGND sky130_fd_sc_hd__edfxtp_1
XFILLER_35_193 VGND VPWR VPWR VGND sky130_fd_sc_hd__decap_12
XFILLER_23_377 VPWR VGND VPWR VGND sky130_fd_sc_hd__decap_3
XFILLER_23_388 VGND VPWR VPWR VGND sky130_fd_sc_hd__decap_4
XFILLER_14_300 VPWR VGND VPWR VGND sky130_fd_sc_hd__decap_8
XPHY_EDGE_ROW_47_Left_119 VPWR VGND VPWR VGND sky130_fd_sc_hd__decap_3
XFILLER_41_60 VGND VPWR VPWR VGND sky130_fd_sc_hd__decap_12
X_1241_ VGND VPWR VGND VPWR _1914_/Q _1913_/Q _1241_/Y _1918_/Q sky130_fd_sc_hd__o21ai_0
X_1310_ VGND VPWR _1321_/B _1313_/C _1915_/Q VPWR VGND sky130_fd_sc_hd__xnor2_1
XFILLER_1_281 VGND VPWR VPWR VGND sky130_fd_sc_hd__decap_12
X_1172_ VGND VPWR VGND VPWR _1259_/A _1304_/C _1172_/X sky130_fd_sc_hd__or2_0
XPHY_EDGE_ROW_56_Left_128 VPWR VGND VPWR VGND sky130_fd_sc_hd__decap_3
XFILLER_52_417 VPWR VGND VPWR VGND sky130_fd_sc_hd__decap_3
XFILLER_2_65 VGND VPWR VPWR VGND sky130_fd_sc_hd__decap_12
X_0956_ VGND VPWR VGND VPWR _1927_/Q _0998_/A1 _0956_/Y _0955_/X sky130_fd_sc_hd__o21ai_0
XPHY_EDGE_ROW_65_Left_137 VPWR VGND VPWR VGND sky130_fd_sc_hd__decap_3
X_0887_ VPWR VGND VPWR VGND _0886_/Y _0885_/B _0892_/B _1995_/Q _1920_/Q sky130_fd_sc_hd__a22oi_1
X_1508_ VPWR VGND VGND VPWR _1680_/A _1508_/B _1944_/D sky130_fd_sc_hd__nor2_1
X_1439_ VGND VPWR VPWR VGND _1704_/D _1448_/B _1852_/Q sky130_fd_sc_hd__and2_0
XFILLER_70_225 VPWR VGND VPWR VGND sky130_fd_sc_hd__decap_8
XFILLER_55_299 VPWR VGND VPWR VGND sky130_fd_sc_hd__decap_6
XFILLER_7_329 VPWR VGND VPWR VGND sky130_fd_sc_hd__decap_6
XFILLER_2_3 VGND VPWR VPWR VGND sky130_fd_sc_hd__decap_12
XFILLER_46_222 VPWR VGND VPWR VGND sky130_fd_sc_hd__decap_6
XPHY_EDGE_ROW_1_Left_73 VPWR VGND VPWR VGND sky130_fd_sc_hd__decap_3
X_1790_ VPWR VGND clkload2/A _1790_/DE _1790_/Q _1790_/D VPWR VGND sky130_fd_sc_hd__edfxtp_1
XFILLER_14_141 VGND VPWR VPWR VGND sky130_fd_sc_hd__decap_4
X_1224_ VGND VPWR VGND VPWR _1221_/Y _1222_/X _1859_/D _1223_/Y sky130_fd_sc_hd__o21ai_0
XFILLER_35_3 VPWR VGND VPWR VGND sky130_fd_sc_hd__decap_8
X_1155_ VGND VPWR _1153_/Y _1151_/Y _1213_/A _1217_/A VPWR VGND sky130_fd_sc_hd__o21ai_1
XFILLER_40_409 VPWR VGND VPWR VGND sky130_fd_sc_hd__decap_8
X_1086_ VGND VPWR VGND VPWR _1085_/Y _1086_/A1 _1919_/D _1084_/Y sky130_fd_sc_hd__o21ai_0
X_1988_ VPWR VGND _1988_/CLK _1678_/Y _1988_/Q _1988_/D VPWR VGND sky130_fd_sc_hd__edfxtp_1
X_0939_ VPWR VGND VGND VPWR _1841_/Q _1842_/Q _0939_/Y _0946_/B sky130_fd_sc_hd__nand3_1
XFILLER_20_133 VPWR VGND VPWR VGND sky130_fd_sc_hd__decap_6
XFILLER_68_391 VGND VPWR VPWR VGND sky130_fd_sc_hd__decap_12
XFILLER_43_225 VGND VPWR VPWR VGND sky130_fd_sc_hd__decap_4
XFILLER_28_277 VPWR VGND VPWR VGND sky130_fd_sc_hd__decap_6
XFILLER_19_211 VGND VPWR VPWR VGND sky130_fd_sc_hd__decap_4
X_1911_ VPWR VGND _1977_/CLK _1917_/DE _1911_/Q _1911_/D VPWR VGND sky130_fd_sc_hd__edfxtp_1
XFILLER_63_91 VPWR VGND VPWR VGND sky130_fd_sc_hd__decap_3
X_1842_ VPWR VGND _1997_/CLK _1869_/DE _1842_/Q _1842_/D VPWR VGND sky130_fd_sc_hd__edfxtp_1
XFILLER_8_53 VPWR VGND VPWR VGND sky130_fd_sc_hd__decap_3
X_1773_ VPWR VGND clkload1/A _1774_/DE _1773_/Q _1773_/D VPWR VGND sky130_fd_sc_hd__edfxtp_1
X_1207_ VPWR VGND VGND VPWR _1878_/D _1207_/B _1207_/Y sky130_fd_sc_hd__nor2_1
XFILLER_57_317 VPWR VGND VPWR VGND sky130_fd_sc_hd__decap_8
X_1138_ VPWR VGND VGND VPWR _1945_/Q _1138_/Y _1140_/B sky130_fd_sc_hd__nand2_1
XFILLER_43_17 VPWR VGND VPWR VGND sky130_fd_sc_hd__decap_3
X_1069_ VPWR VGND VGND VPWR _1068_/X _1069_/Y _1067_/X _1084_/S sky130_fd_sc_hd__mux2i_1
XFILLER_8_413 VPWR VGND VPWR VGND sky130_fd_sc_hd__decap_6
X_2041_ VPWR VGND _2041_/X _2041_/A VPWR VGND sky130_fd_sc_hd__buf_2
Xhold402 _1872_/D _1916_/Q VPWR VGND VGND VPWR sky130_fd_sc_hd__dlygate4sd3_1
Xhold413 hold413/X _1991_/Q VPWR VGND VGND VPWR sky130_fd_sc_hd__dlygate4sd3_1
X_1825_ _1825_/Q _2000_/CLK _1825_/D VPWR VGND VPWR VGND sky130_fd_sc_hd__dfxtp_1
X_1756_ VPWR VGND clkload5/A _1758_/DE _1756_/Q _1756_/D VPWR VGND sky130_fd_sc_hd__edfxtp_1
X_1687_ VPWR VGND VGND VPWR _1693_/A _1687_/Y sky130_fd_sc_hd__inv_1
XFILLER_57_169 VPWR VGND VPWR VGND sky130_fd_sc_hd__decap_3
XFILLER_57_158 VPWR VGND VPWR VGND sky130_fd_sc_hd__decap_8
XFILLER_38_383 VPWR VGND VPWR VGND sky130_fd_sc_hd__decap_3
XFILLER_70_37 VPWR VGND VPWR VGND sky130_fd_sc_hd__decap_3
XFILLER_70_15 VGND VPWR VPWR VGND sky130_fd_sc_hd__decap_12
XFILLER_5_405 VGND VPWR VPWR VGND sky130_fd_sc_hd__decap_12
XFILLER_63_106 VPWR VGND VPWR VGND sky130_fd_sc_hd__decap_6
XFILLER_36_309 VPWR VGND VPWR VGND sky130_fd_sc_hd__decap_8
XFILLER_0_165 VPWR VGND VPWR VGND sky130_fd_sc_hd__decap_3
XFILLER_44_60 VGND VPWR VPWR VGND sky130_fd_sc_hd__decap_4
X_1610_ VPWR VGND VGND VPWR _1610_/C _1610_/B _1680_/A _1976_/D sky130_fd_sc_hd__nor3_1
XFILLER_60_92 VPWR VGND VPWR VGND sky130_fd_sc_hd__decap_3
XFILLER_12_294 VPWR VGND VPWR VGND sky130_fd_sc_hd__decap_8
X_1472_ VGND VPWR VGND VPWR _2017_/A _1573_/A _1682_/A _1471_/Y _1470_/Y _1965_/D
+ sky130_fd_sc_hd__a2111oi_2
X_1541_ VPWR VGND VGND VPWR _2020_/A _2021_/A _1573_/B _1576_/B sky130_fd_sc_hd__nand3_1
X_2024_ VPWR VGND _2024_/X _2024_/A VPWR VGND sky130_fd_sc_hd__buf_2
XFILLER_39_169 VGND VPWR VPWR VGND sky130_fd_sc_hd__decap_12
XFILLER_39_158 VPWR VGND VPWR VGND sky130_fd_sc_hd__decap_3
XFILLER_10_209 VPWR VGND VPWR VGND sky130_fd_sc_hd__decap_6
X_1808_ VPWR VGND _1895_/CLK _1817_/DE _1808_/Q _1808_/D VPWR VGND sky130_fd_sc_hd__edfxtp_1
X_1739_ VPWR VGND clkload3/A _1742_/DE _1739_/Q _1739_/D VPWR VGND sky130_fd_sc_hd__edfxtp_1
XFILLER_18_309 VPWR VGND VPWR VGND sky130_fd_sc_hd__decap_8
XFILLER_14_85 VPWR VGND VPWR VGND sky130_fd_sc_hd__decap_8
XFILLER_30_62 VGND VPWR VPWR VGND sky130_fd_sc_hd__decap_12
XFILLER_71_80 VGND VPWR VPWR VGND sky130_fd_sc_hd__decap_4
X_0972_ VGND VPWR VGND VPWR _1924_/Q _0998_/A1 _0972_/Y _0971_/X sky130_fd_sc_hd__o21ai_0
XFILLER_32_389 VPWR VGND VPWR VGND sky130_fd_sc_hd__decap_3
XFILLER_17_375 VGND VPWR VPWR VGND sky130_fd_sc_hd__decap_12
Xoutput315 VPWR VGND mem_addr[0] _1253_/X VPWR VGND sky130_fd_sc_hd__buf_4
Xoutput326 VPWR VGND mem_addr[9] _1243_/X VPWR VGND sky130_fd_sc_hd__buf_4
Xoutput304 VPWR VGND dbg_pc[10] _2027_/X VPWR VGND sky130_fd_sc_hd__buf_4
XFILLER_65_3 VGND VPWR VPWR VGND sky130_fd_sc_hd__decap_12
X_1524_ VPWR VGND VGND VPWR _1688_/A _1524_/B _1936_/D sky130_fd_sc_hd__nor2_1
Xoutput337 VPWR VGND mem_wdata[4] _2033_/X VPWR VGND sky130_fd_sc_hd__buf_4
X_1455_ VPWR VGND VGND VPWR _1455_/A _1455_/B _1456_/S _1455_/C sky130_fd_sc_hd__nand3_1
X_1386_ VGND VPWR VPWR VGND _1761_/D _1386_/B _1845_/Q sky130_fd_sc_hd__and2_0
X_2007_ VPWR VGND _2007_/CLK _2008_/DE _2007_/Q _2007_/D VPWR VGND sky130_fd_sc_hd__edfxtp_1
XFILLER_61_407 VGND VPWR VPWR VGND sky130_fd_sc_hd__decap_12
XFILLER_58_253 VGND VPWR VPWR VGND sky130_fd_sc_hd__decap_12
XFILLER_18_117 VGND VPWR VPWR VGND sky130_fd_sc_hd__decap_12
XFILLER_25_51 VGND VPWR VPWR VGND sky130_fd_sc_hd__decap_4
XFILLER_51_9 VGND VPWR VPWR VGND sky130_fd_sc_hd__decap_12
X_1240_ VPWR VGND _1240_/X _1914_/Q _1918_/Q VPWR VGND sky130_fd_sc_hd__and2_1
X_1171_ VPWR VGND VGND VPWR _1304_/C _1259_/A _1305_/C sky130_fd_sc_hd__nor2_1
XFILLER_2_77 VPWR VGND VPWR VGND sky130_fd_sc_hd__decap_6
XFILLER_1_293 VGND VPWR VPWR VGND sky130_fd_sc_hd__decap_12
XFILLER_49_297 VPWR VGND VPWR VGND sky130_fd_sc_hd__decap_8
X_0955_ VGND VPWR VPWR VGND _0955_/X _1882_/Q _0997_/A sky130_fd_sc_hd__and2_0
X_0886_ VPWR VGND VGND VPWR _1920_/Q _0886_/Y _1919_/Q sky130_fd_sc_hd__nand2_1
XFILLER_32_197 VPWR VGND VPWR VGND sky130_fd_sc_hd__decap_6
XFILLER_9_393 VGND VPWR VPWR VGND sky130_fd_sc_hd__decap_12
X_1507_ VPWR VGND VGND VPWR _1839_/D _1508_/B _2025_/A _1606_/C sky130_fd_sc_hd__mux2i_1
X_1369_ VGND VPWR VPWR VGND _1779_/D _1630_/B _1847_/Q sky130_fd_sc_hd__and2_0
X_1438_ VGND VPWR VPWR VGND _1705_/D _1525_/B _1853_/Q sky130_fd_sc_hd__and2_0
XFILLER_11_315 VGND VPWR VPWR VGND sky130_fd_sc_hd__decap_12
XFILLER_11_337 VGND VPWR VPWR VGND sky130_fd_sc_hd__decap_12
XFILLER_46_289 VGND VPWR VPWR VGND sky130_fd_sc_hd__decap_12
XFILLER_14_197 VGND VPWR VPWR VGND sky130_fd_sc_hd__decap_12
XFILLER_69_337 VPWR VGND VPWR VGND sky130_fd_sc_hd__decap_6
X_1154_ VGND VPWR VPWR VGND _1937_/Q _1217_/B _1219_/A sky130_fd_sc_hd__xor2_1
X_1223_ VPWR VGND VPWR VGND _1222_/C _1936_/Q _1357_/A _1223_/Y sky130_fd_sc_hd__a21oi_1
XFILLER_28_3 VGND VPWR VPWR VGND sky130_fd_sc_hd__decap_12
X_1085_ VPWR VGND VGND VPWR _1357_/A _1085_/Y _1085_/B sky130_fd_sc_hd__nand2_1
X_1987_ VPWR VGND _1987_/CLK _1679_/Y _1987_/Q _1987_/D VPWR VGND sky130_fd_sc_hd__edfxtp_1
X_0938_ VPWR VGND VGND VPWR _1841_/Q _0947_/B _0946_/B sky130_fd_sc_hd__nand2_1
X_0869_ VPWR VGND VPWR VGND _1928_/Q _0875_/A _0878_/B _0877_/B sky130_fd_sc_hd__a21o_1
XFILLER_51_281 VPWR VGND VPWR VGND sky130_fd_sc_hd__decap_3
XFILLER_22_85 VPWR VGND VPWR VGND sky130_fd_sc_hd__decap_8
X_1910_ VPWR VGND _1977_/CLK _1917_/DE _1910_/Q _1910_/D VPWR VGND sky130_fd_sc_hd__edfxtp_1
XFILLER_63_81 VPWR VGND VPWR VGND sky130_fd_sc_hd__decap_3
XFILLER_30_421 VGND VPWR VPWR VGND sky130_fd_sc_hd__decap_4
X_1841_ VPWR VGND _1997_/CLK _1358_/D _1841_/Q _1841_/D VPWR VGND sky130_fd_sc_hd__edfxtp_1
X_1772_ VPWR VGND clkload6/A _1774_/DE _1772_/Q _1772_/D VPWR VGND sky130_fd_sc_hd__edfxtp_1
XFILLER_69_101 VPWR VGND VPWR VGND sky130_fd_sc_hd__decap_8
X_1206_ VPWR VGND VPWR VGND _1218_/A _1952_/Q _1221_/B _1206_/Y sky130_fd_sc_hd__a21oi_1
X_1137_ VPWR VGND VGND VPWR _1945_/Q _1140_/B _1166_/A sky130_fd_sc_hd__nor2_1
XFILLER_33_281 VGND VPWR VPWR VGND sky130_fd_sc_hd__decap_4
X_1068_ VGND VPWR VGND VPWR _1073_/S0 _1778_/Q _1762_/Q _1824_/Q _1794_/Q _1810_/Q
+ _1068_/X sky130_fd_sc_hd__mux4_2
XFILLER_68_15 VGND VPWR VPWR VGND sky130_fd_sc_hd__decap_12
XFILLER_71_343 VGND VPWR VPWR VGND sky130_fd_sc_hd__decap_12
XFILLER_12_421 VGND VPWR VPWR VGND sky130_fd_sc_hd__decap_4
XFILLER_16_248 VGND VPWR VPWR VGND sky130_fd_sc_hd__decap_4
XFILLER_58_81 VPWR VGND VPWR VGND sky130_fd_sc_hd__decap_3
X_2040_ VPWR VGND _2040_/X _2040_/A VPWR VGND sky130_fd_sc_hd__buf_2
XFILLER_62_365 VGND VPWR VPWR VGND sky130_fd_sc_hd__decap_12
XFILLER_15_281 VPWR VGND VPWR VGND sky130_fd_sc_hd__decap_8
Xhold414 hold414/X _1863_/Q VPWR VGND VGND VPWR sky130_fd_sc_hd__dlygate4sd3_1
Xhold403 hold403/X _1964_/Q VPWR VGND VGND VPWR sky130_fd_sc_hd__dlygate4sd3_1
X_1686_ VPWR VGND VGND VPWR _1686_/A _1686_/Y sky130_fd_sc_hd__inv_1
X_1824_ _1824_/Q _1979_/CLK _1824_/D VPWR VGND VPWR VGND sky130_fd_sc_hd__dfxtp_1
X_1755_ VPWR VGND clkload3/A _1758_/DE _1755_/Q _1755_/D VPWR VGND sky130_fd_sc_hd__edfxtp_1
XFILLER_57_104 VPWR VGND VPWR VGND sky130_fd_sc_hd__decap_8
XFILLER_38_29 VGND VPWR VPWR VGND sky130_fd_sc_hd__decap_12
XFILLER_5_417 VPWR VGND VPWR VGND sky130_fd_sc_hd__decap_8
XFILLER_44_365 VPWR VGND VPWR VGND sky130_fd_sc_hd__decap_3
X_1540_ VGND VPWR _1542_/C _2021_/A _2020_/A _1576_/B VPWR VGND sky130_fd_sc_hd__and3_1
XFILLER_8_277 VGND VPWR VPWR VGND sky130_fd_sc_hd__decap_12
XFILLER_12_284 VGND VPWR VPWR VGND sky130_fd_sc_hd__decap_4
X_1471_ VPWR VGND VGND VPWR _1459_/B _1859_/Q _1471_/Y sky130_fd_sc_hd__nor2b_1
XFILLER_10_3 VGND VPWR VPWR VGND sky130_fd_sc_hd__decap_12
X_2023_ VPWR VGND _2023_/X _2023_/A VPWR VGND sky130_fd_sc_hd__buf_2
XFILLER_62_151 VGND VPWR VPWR VGND sky130_fd_sc_hd__decap_12
XFILLER_54_118 VGND VPWR VPWR VGND sky130_fd_sc_hd__decap_4
XFILLER_50_324 VGND VPWR VPWR VGND sky130_fd_sc_hd__decap_4
X_1807_ VPWR VGND _1807_/CLK _1817_/DE _1807_/Q _1807_/D VPWR VGND sky130_fd_sc_hd__edfxtp_1
X_1669_ VPWR VGND VGND VPWR _1693_/A _1669_/Y sky130_fd_sc_hd__inv_1
X_1738_ VPWR VGND _2015_/CLK _1742_/DE _1738_/Q _1738_/D VPWR VGND sky130_fd_sc_hd__edfxtp_1
XFILLER_41_324 VGND VPWR VPWR VGND sky130_fd_sc_hd__decap_12
XFILLER_26_376 VGND VPWR VPWR VGND sky130_fd_sc_hd__decap_12
XFILLER_26_365 VPWR VGND VPWR VGND sky130_fd_sc_hd__decap_6
XFILLER_5_225 VGND VPWR VPWR VGND sky130_fd_sc_hd__decap_12
XFILLER_14_64 VGND VPWR VPWR VGND sky130_fd_sc_hd__decap_12
XFILLER_30_85 VGND VPWR VPWR VGND sky130_fd_sc_hd__decap_12
XFILLER_17_387 VGND VPWR VPWR VGND sky130_fd_sc_hd__decap_4
X_0971_ VGND VPWR VPWR VGND _0971_/X _1879_/Q _0997_/A sky130_fd_sc_hd__and2_0
Xoutput316 VPWR VGND mem_addr[10] _1242_/X VPWR VGND sky130_fd_sc_hd__buf_4
Xoutput305 VPWR VGND dbg_pc[11] _2028_/X VPWR VGND sky130_fd_sc_hd__buf_4
X_1523_ VPWR VGND VGND VPWR _1831_/D _1524_/B _2017_/A _1573_/A sky130_fd_sc_hd__mux2i_1
XFILLER_58_3 VGND VPWR VPWR VGND sky130_fd_sc_hd__decap_4
X_1454_ VPWR VGND VGND VPWR _1454_/C _1878_/Q _1879_/Q _1455_/C sky130_fd_sc_hd__nor3_1
Xoutput338 VPWR VGND mem_wdata[5] _2034_/X VPWR VGND sky130_fd_sc_hd__buf_4
Xoutput327 VPWR VGND mem_wdata[0] _2029_/X VPWR VGND sky130_fd_sc_hd__buf_4
XFILLER_67_287 VGND VPWR VPWR VGND sky130_fd_sc_hd__decap_4
XFILLER_67_221 VPWR VGND VPWR VGND sky130_fd_sc_hd__decap_3
XFILLER_27_107 VGND VPWR VPWR VGND sky130_fd_sc_hd__decap_4
X_1385_ VGND VPWR VPWR VGND _1762_/D _1529_/B _1846_/Q sky130_fd_sc_hd__and2_0
X_2006_ VPWR VGND _2006_/CLK _2008_/DE _2006_/Q _2006_/D VPWR VGND sky130_fd_sc_hd__edfxtp_1
XFILLER_58_232 VPWR VGND VPWR VGND sky130_fd_sc_hd__decap_8
XFILLER_58_265 VGND VPWR VPWR VGND sky130_fd_sc_hd__decap_12
Xclkbuf_leaf_38_clk clkload3/A clkbuf_leaf_2_clk/A VPWR VGND VGND VPWR sky130_fd_sc_hd__clkbuf_8
XFILLER_18_129 VPWR VGND VPWR VGND sky130_fd_sc_hd__decap_8
XFILLER_41_187 VPWR VGND VPWR VGND sky130_fd_sc_hd__decap_8
XFILLER_44_9 VGND VPWR VPWR VGND sky130_fd_sc_hd__decap_12
X_1170_ VPWR VGND VGND VPWR _1169_/Y _1353_/C _1259_/A sky130_fd_sc_hd__nand2b_1
XFILLER_1_261 VGND VPWR VPWR VGND sky130_fd_sc_hd__decap_12
Xclkbuf_leaf_29_clk _2001_/CLK clkbuf_3_4__f_clk/X VPWR VGND VGND VPWR sky130_fd_sc_hd__clkbuf_8
XFILLER_17_162 VPWR VGND VPWR VGND sky130_fd_sc_hd__decap_6
X_0954_ VGND VPWR _0954_/B _0954_/Y _0954_/A VPWR VGND sky130_fd_sc_hd__xnor2_1
X_0885_ VGND VPWR _0885_/B _0894_/B _1921_/Q VPWR VGND sky130_fd_sc_hd__xnor2_1
XFILLER_9_361 VGND VPWR VPWR VGND sky130_fd_sc_hd__decap_12
X_1506_ VPWR VGND VGND VPWR _1680_/A _1506_/B _1945_/D sky130_fd_sc_hd__nor2_1
X_1437_ VGND VPWR VPWR VGND _1706_/D _1525_/B _1854_/Q sky130_fd_sc_hd__and2_0
X_1299_ VPWR VGND VGND VPWR _1914_/Q _1302_/B _1830_/Q sky130_fd_sc_hd__nand2_1
X_1368_ VGND VPWR VPWR VGND _1780_/D _1630_/B _1848_/Q sky130_fd_sc_hd__and2_0
XFILLER_23_154 VPWR VGND VPWR VGND sky130_fd_sc_hd__decap_8
X_1153_ VPWR VGND VGND VPWR _1937_/Q _1219_/A _1153_/Y sky130_fd_sc_hd__nor2_1
X_1222_ VGND VPWR _1222_/X _1357_/A _1936_/Q _1222_/C VPWR VGND sky130_fd_sc_hd__and3_1
XFILLER_37_268 VGND VPWR VPWR VGND sky130_fd_sc_hd__decap_12
X_1084_ VPWR VGND VGND VPWR _1083_/X _1084_/Y _1082_/X _1084_/S sky130_fd_sc_hd__mux2i_1
X_1986_ VPWR VGND _1986_/CLK _1680_/Y _1986_/Q _1986_/D VPWR VGND sky130_fd_sc_hd__edfxtp_1
Xclkbuf_leaf_9_clk clkload8/A clkbuf_leaf_9_clk/A VPWR VGND VGND VPWR sky130_fd_sc_hd__clkbuf_8
X_0937_ VPWR VGND VGND VPWR _1839_/Q _1840_/Q _0937_/Y _0957_/B sky130_fd_sc_hd__nand3_1
X_0868_ VPWR VGND VGND VPWR _1995_/Q _0868_/B _0878_/B sky130_fd_sc_hd__nor2_1
XFILLER_43_216 VPWR VGND VPWR VGND sky130_fd_sc_hd__decap_8
XFILLER_28_235 VPWR VGND VPWR VGND sky130_fd_sc_hd__decap_8
XFILLER_16_408 VGND VPWR VPWR VGND sky130_fd_sc_hd__decap_12
XFILLER_11_113 VGND VPWR VPWR VGND sky130_fd_sc_hd__decap_12
XFILLER_59_393 VPWR VGND VPWR VGND sky130_fd_sc_hd__decap_8
X_1840_ VPWR VGND _1988_/CLK _1869_/DE _1840_/Q _1840_/D VPWR VGND sky130_fd_sc_hd__edfxtp_1
Xclkbuf_3_4__f_clk VGND VPWR VGND VPWR clkbuf_0_clk/X clkbuf_3_4__f_clk/X sky130_fd_sc_hd__clkbuf_16
X_1771_ VPWR VGND _2016_/CLK _1774_/DE _1771_/Q _1771_/D VPWR VGND sky130_fd_sc_hd__edfxtp_1
XFILLER_69_157 VPWR VGND VPWR VGND sky130_fd_sc_hd__decap_8
XFILLER_69_113 VPWR VGND VPWR VGND sky130_fd_sc_hd__decap_6
X_1136_ VGND VPWR _1140_/B _1136_/Y _1946_/Q VPWR VGND sky130_fd_sc_hd__xnor2_1
X_1205_ VPWR VGND VGND VPWR _1205_/A _1205_/Y _1205_/B sky130_fd_sc_hd__nand2_1
X_1067_ VGND VPWR VGND VPWR _1073_/S0 _1714_/Q _1698_/Q _1824_/Q _1730_/Q _1746_/Q
+ _1067_/X sky130_fd_sc_hd__mux4_2
XFILLER_25_249 VGND VPWR VPWR VGND sky130_fd_sc_hd__decap_4
X_1969_ _2021_/A _1969_/CLK _1969_/D VPWR VGND VPWR VGND sky130_fd_sc_hd__dfxtp_1
XFILLER_33_271 VPWR VGND VPWR VGND sky130_fd_sc_hd__decap_8
XFILLER_68_49 VPWR VGND VPWR VGND sky130_fd_sc_hd__decap_3
XFILLER_4_109 VGND VPWR VPWR VGND sky130_fd_sc_hd__decap_12
XFILLER_0_337 VGND VPWR VPWR VGND sky130_fd_sc_hd__decap_12
XFILLER_71_300 VPWR VGND VPWR VGND sky130_fd_sc_hd__decap_8
XFILLER_48_319 VGND VPWR VPWR VGND sky130_fd_sc_hd__decap_4
XFILLER_71_355 VPWR VGND VPWR VGND sky130_fd_sc_hd__decap_8
XFILLER_71_333 VPWR VGND VPWR VGND sky130_fd_sc_hd__decap_3
XFILLER_17_53 VPWR VGND VPWR VGND sky130_fd_sc_hd__decap_3
XFILLER_17_86 VPWR VGND VPWR VGND sky130_fd_sc_hd__decap_8
XFILLER_59_190 VPWR VGND VPWR VGND sky130_fd_sc_hd__decap_6
XFILLER_62_377 VGND VPWR VPWR VGND sky130_fd_sc_hd__decap_4
X_1823_ _1823_/Q _2006_/CLK _1823_/D VPWR VGND VPWR VGND sky130_fd_sc_hd__dfxtp_1
XFILLER_30_296 VGND VPWR VPWR VGND sky130_fd_sc_hd__decap_12
Xhold415 hold415/X _1864_/Q VPWR VGND VGND VPWR sky130_fd_sc_hd__dlygate4sd3_1
Xhold404 _1841_/D _1946_/Q VPWR VGND VGND VPWR sky130_fd_sc_hd__dlygate4sd3_1
X_1685_ VPWR VGND VGND VPWR _1693_/A _1685_/Y sky130_fd_sc_hd__inv_1
X_1754_ VPWR VGND _2000_/CLK _1754_/DE _1754_/Q _1754_/D VPWR VGND sky130_fd_sc_hd__edfxtp_1
XFILLER_65_193 VPWR VGND VPWR VGND sky130_fd_sc_hd__decap_3
XFILLER_54_29 VPWR VGND VPWR VGND sky130_fd_sc_hd__decap_6
X_1119_ VGND VPWR VPWR VGND _1878_/D _1117_/X _1131_/S _1118_/X sky130_fd_sc_hd__mux2_1
XPHY_EDGE_ROW_17_Right_17 VPWR VGND VPWR VGND sky130_fd_sc_hd__decap_3
XPHY_EDGE_ROW_26_Right_26 VPWR VGND VPWR VGND sky130_fd_sc_hd__decap_3
XFILLER_56_193 VPWR VGND VPWR VGND sky130_fd_sc_hd__decap_3
XFILLER_28_85 VPWR VGND VPWR VGND sky130_fd_sc_hd__decap_8
XPHY_EDGE_ROW_35_Right_35 VPWR VGND VPWR VGND sky130_fd_sc_hd__decap_3
X_1470_ VPWR VGND VGND VPWR _2017_/A _1553_/B _1470_/Y sky130_fd_sc_hd__nor2_1
XFILLER_8_289 VGND VPWR VPWR VGND sky130_fd_sc_hd__decap_12
XPHY_EDGE_ROW_44_Right_44 VPWR VGND VPWR VGND sky130_fd_sc_hd__decap_3
X_2022_ VPWR VGND _2022_/X _2022_/A VPWR VGND sky130_fd_sc_hd__buf_2
XFILLER_62_163 VPWR VGND VPWR VGND sky130_fd_sc_hd__decap_3
XPHY_EDGE_ROW_53_Right_53 VPWR VGND VPWR VGND sky130_fd_sc_hd__decap_3
XFILLER_50_336 VPWR VGND VPWR VGND sky130_fd_sc_hd__decap_3
X_1806_ VPWR VGND _2016_/CLK _1806_/DE _1806_/Q _1806_/D VPWR VGND sky130_fd_sc_hd__edfxtp_1
XPHY_EDGE_ROW_17_Left_89 VPWR VGND VPWR VGND sky130_fd_sc_hd__decap_3
XPHY_EDGE_ROW_62_Right_62 VPWR VGND VPWR VGND sky130_fd_sc_hd__decap_3
X_1668_ VPWR VGND VGND VPWR _1693_/A _1668_/Y sky130_fd_sc_hd__inv_1
X_1599_ VGND VPWR VPWR VGND _1805_/D _1613_/B _1857_/Q sky130_fd_sc_hd__and2_0
X_1737_ VPWR VGND _1749_/CLK _1737_/DE _1737_/Q _1737_/D VPWR VGND sky130_fd_sc_hd__edfxtp_1
XFILLER_53_141 VPWR VGND VPWR VGND sky130_fd_sc_hd__decap_3
XPHY_EDGE_ROW_71_Right_71 VPWR VGND VPWR VGND sky130_fd_sc_hd__decap_3
XFILLER_26_399 VGND VPWR VPWR VGND sky130_fd_sc_hd__decap_12
XFILLER_14_76 VPWR VGND VPWR VGND sky130_fd_sc_hd__decap_8
XFILLER_30_97 VPWR VGND VPWR VGND sky130_fd_sc_hd__decap_3
XFILLER_49_414 VPWR VGND VPWR VGND sky130_fd_sc_hd__decap_6
XFILLER_44_141 VGND VPWR VPWR VGND sky130_fd_sc_hd__decap_12
XFILLER_32_303 VGND VPWR VPWR VGND sky130_fd_sc_hd__decap_4
X_0970_ VGND VPWR _0970_/B _0970_/Y _0970_/A VPWR VGND sky130_fd_sc_hd__xnor2_1
Xoutput306 VPWR VGND dbg_pc[1] _2018_/X VPWR VGND sky130_fd_sc_hd__buf_4
Xoutput317 VPWR VGND mem_addr[11] _1350_/X VPWR VGND sky130_fd_sc_hd__buf_4
X_1522_ VPWR VGND VGND VPWR _1522_/A _1522_/B _1937_/D sky130_fd_sc_hd__nor2_1
X_1453_ VPWR VGND VPWR VGND _1885_/Q _1881_/Q _1882_/Q _1888_/Q _1454_/C sky130_fd_sc_hd__or4_1
Xoutput339 VPWR VGND mem_wdata[6] _2035_/X VPWR VGND sky130_fd_sc_hd__buf_4
Xoutput328 VPWR VGND mem_wdata[10] _2039_/X VPWR VGND sky130_fd_sc_hd__buf_4
XFILLER_67_277 VPWR VGND VPWR VGND sky130_fd_sc_hd__decap_3
X_1384_ VGND VPWR VPWR VGND _1763_/D _1386_/B _1847_/Q sky130_fd_sc_hd__and2_0
X_2005_ VPWR VGND _2006_/CLK _2008_/DE _2005_/Q _2005_/D VPWR VGND sky130_fd_sc_hd__edfxtp_1
XFILLER_58_299 VPWR VGND VPWR VGND sky130_fd_sc_hd__decap_6
XFILLER_58_277 VPWR VGND VPWR VGND sky130_fd_sc_hd__decap_3
XFILLER_41_100 VPWR VGND VPWR VGND sky130_fd_sc_hd__decap_8
XFILLER_26_141 VGND VPWR VPWR VGND sky130_fd_sc_hd__decap_12
XFILLER_64_236 VPWR VGND VPWR VGND sky130_fd_sc_hd__decap_8
XFILLER_49_200 VPWR VGND VPWR VGND sky130_fd_sc_hd__decap_8
XFILLER_1_273 VPWR VGND VPWR VGND sky130_fd_sc_hd__decap_6
XFILLER_70_3 VGND VPWR VPWR VGND sky130_fd_sc_hd__decap_12
X_0953_ VGND VPWR VGND VPWR _0952_/Y _1367_/A1 _1987_/D _0949_/Y sky130_fd_sc_hd__o21ai_0
X_0884_ VGND VPWR _0884_/B _0896_/B _0884_/A VPWR VGND sky130_fd_sc_hd__xnor2_1
XFILLER_9_373 VGND VPWR VPWR VGND sky130_fd_sc_hd__decap_12
XFILLER_13_380 VGND VPWR VPWR VGND sky130_fd_sc_hd__decap_12
X_1505_ VPWR VGND VGND VPWR _1840_/D _1506_/B _2026_/A _1606_/C sky130_fd_sc_hd__mux2i_1
X_1367_ VPWR VGND VGND VPWR _1367_/A1 _1365_/Y _1366_/Y _0851_/Y _1993_/D sky130_fd_sc_hd__o22ai_1
XPHY_EDGE_ROW_34_Left_106 VPWR VGND VPWR VGND sky130_fd_sc_hd__decap_3
X_1436_ VGND VPWR VPWR VGND _1707_/D _1525_/B _1855_/Q sky130_fd_sc_hd__and2_0
XFILLER_70_239 VPWR VGND VPWR VGND sky130_fd_sc_hd__decap_3
X_1298_ VGND VPWR VPWR VGND _1958_/Q _1302_/A _1872_/Q sky130_fd_sc_hd__xor2_1
XPHY_EDGE_ROW_43_Left_115 VPWR VGND VPWR VGND sky130_fd_sc_hd__decap_3
Xplace280 VPWR VGND _1064_/S1 _1824_/Q VPWR VGND sky130_fd_sc_hd__buf_2
XFILLER_23_177 VPWR VGND VPWR VGND sky130_fd_sc_hd__decap_3
XPHY_EDGE_ROW_52_Left_124 VPWR VGND VPWR VGND sky130_fd_sc_hd__decap_3
XFILLER_61_217 VPWR VGND VPWR VGND sky130_fd_sc_hd__decap_3
XPHY_EDGE_ROW_61_Left_133 VPWR VGND VPWR VGND sky130_fd_sc_hd__decap_3
XFILLER_36_85 VGND VPWR VPWR VGND sky130_fd_sc_hd__decap_12
XFILLER_14_111 VGND VPWR VPWR VGND sky130_fd_sc_hd__decap_4
XFILLER_14_133 VPWR VGND VPWR VGND sky130_fd_sc_hd__decap_6
XPHY_EDGE_ROW_70_Left_142 VPWR VGND VPWR VGND sky130_fd_sc_hd__decap_3
XFILLER_6_321 VGND VPWR VPWR VGND sky130_fd_sc_hd__decap_12
XFILLER_6_365 VGND VPWR VPWR VGND sky130_fd_sc_hd__decap_12
X_1221_ VPWR VGND VGND VPWR _1874_/D _1221_/Y _1221_/B sky130_fd_sc_hd__nand2_1
X_1152_ VPWR VGND VGND VPWR _1936_/Q _1217_/A _1357_/A sky130_fd_sc_hd__nand2_1
XFILLER_37_225 VGND VPWR VPWR VGND sky130_fd_sc_hd__decap_12
X_1083_ VGND VPWR VGND VPWR _1083_/S0 _1775_/Q _1759_/Q _1083_/S1 _1791_/Q _1807_/Q
+ _1083_/X sky130_fd_sc_hd__mux4_2
X_1985_ VPWR VGND _1987_/CLK _1681_/Y _1985_/Q _1985_/D VPWR VGND sky130_fd_sc_hd__edfxtp_1
X_0936_ VGND VPWR _0946_/B _1840_/Q _1839_/Q _0957_/B VPWR VGND sky130_fd_sc_hd__and3_1
X_0867_ VPWR VGND VPWR VGND _0866_/B _0857_/A _1995_/Q _0879_/B sky130_fd_sc_hd__a21oi_1
X_1419_ VGND VPWR VPWR VGND _1725_/D _1526_/B _1857_/Q sky130_fd_sc_hd__and2_0
XFILLER_11_125 VPWR VGND VPWR VGND sky130_fd_sc_hd__decap_8
XFILLER_11_169 VGND VPWR VPWR VGND sky130_fd_sc_hd__decap_12
XPHY_EDGE_ROW_5_Left_77 VPWR VGND VPWR VGND sky130_fd_sc_hd__decap_3
XFILLER_0_3 VGND VPWR VPWR VGND sky130_fd_sc_hd__decap_12
XFILLER_19_225 VGND VPWR VPWR VGND sky130_fd_sc_hd__decap_12
X_1770_ VPWR VGND _2000_/CLK _1770_/DE _1770_/Q _1770_/D VPWR VGND sky130_fd_sc_hd__edfxtp_1
XFILLER_8_67 VGND VPWR VPWR VGND sky130_fd_sc_hd__decap_12
XFILLER_69_147 VGND VPWR VPWR VGND sky130_fd_sc_hd__decap_4
X_1204_ VPWR VGND VGND VPWR _1204_/A _1218_/A _1205_/B sky130_fd_sc_hd__nor2_1
XFILLER_33_3 VGND VPWR VPWR VGND sky130_fd_sc_hd__decap_12
X_1135_ VPWR VGND VGND VPWR _1946_/Q _1140_/B _1135_/Y sky130_fd_sc_hd__nor2b_1
X_1066_ VGND VPWR VGND VPWR _1062_/Y _1086_/A1 _1923_/D _1065_/Y sky130_fd_sc_hd__o21ai_0
X_1968_ _2020_/A _1969_/CLK _1968_/D VPWR VGND VPWR VGND sky130_fd_sc_hd__dfxtp_1
X_0919_ VGND VPWR _1361_/C _0920_/B _1888_/Q VPWR VGND sky130_fd_sc_hd__xnor2_1
X_1899_ VPWR VGND _2006_/CLK _1641_/Y _2034_/A _1899_/D VPWR VGND sky130_fd_sc_hd__edfxtp_1
XFILLER_33_294 VPWR VGND VPWR VGND sky130_fd_sc_hd__decap_6
XFILLER_17_21 VGND VPWR VPWR VGND sky130_fd_sc_hd__decap_12
XFILLER_12_401 VGND VPWR VPWR VGND sky130_fd_sc_hd__decap_12
XFILLER_59_180 VPWR VGND VPWR VGND sky130_fd_sc_hd__decap_6
XFILLER_62_356 VPWR VGND VPWR VGND sky130_fd_sc_hd__decap_8
X_1753_ VPWR VGND clkload1/A _1754_/DE _1753_/Q _1753_/D VPWR VGND sky130_fd_sc_hd__edfxtp_1
X_1822_ VPWR VGND _2016_/CLK _1822_/DE _1822_/Q _1822_/D VPWR VGND sky130_fd_sc_hd__edfxtp_1
Xhold405 hold405/X _1935_/Q VPWR VGND VGND VPWR sky130_fd_sc_hd__dlygate4sd3_1
Xhold416 hold416/X _1939_/Q VPWR VGND VGND VPWR sky130_fd_sc_hd__dlygate4sd3_1
X_1684_ VPWR VGND VGND VPWR _1693_/A _1684_/Y sky130_fd_sc_hd__inv_1
XFILLER_57_128 VGND VPWR VPWR VGND sky130_fd_sc_hd__decap_12
XFILLER_38_320 VPWR VGND VPWR VGND sky130_fd_sc_hd__decap_3
XFILLER_70_29 VPWR VGND VPWR VGND sky130_fd_sc_hd__decap_8
XFILLER_53_345 VGND VPWR VPWR VGND sky130_fd_sc_hd__decap_12
X_1118_ VGND VPWR VGND VPWR _1127_/S0 _1747_/Q _1715_/Q _1127_/S1 _1779_/Q _1811_/Q
+ _1118_/X sky130_fd_sc_hd__mux4_2
X_1049_ VGND VPWR VGND VPWR _1083_/S0 _1782_/Q _1766_/Q _1083_/S1 _1798_/Q _1814_/Q
+ _1049_/X sky130_fd_sc_hd__mux4_2
XFILLER_0_113 VGND VPWR VPWR VGND sky130_fd_sc_hd__decap_12
XFILLER_71_175 VGND VPWR VPWR VGND sky130_fd_sc_hd__decap_12
XFILLER_28_53 VPWR VGND VPWR VGND sky130_fd_sc_hd__decap_6
XFILLER_12_253 VPWR VGND VPWR VGND sky130_fd_sc_hd__decap_6
XFILLER_5_57 VGND VPWR VPWR VGND sky130_fd_sc_hd__decap_12
X_2021_ VPWR VGND _2021_/X _2021_/A VPWR VGND sky130_fd_sc_hd__buf_2
XPHY_EDGE_ROW_8_Left_80 VPWR VGND VPWR VGND sky130_fd_sc_hd__decap_3
XFILLER_62_120 VGND VPWR VPWR VGND sky130_fd_sc_hd__decap_4
XFILLER_47_194 VGND VPWR VPWR VGND sky130_fd_sc_hd__decap_12
XFILLER_35_356 VPWR VGND VPWR VGND sky130_fd_sc_hd__decap_8
X_1805_ VPWR VGND clkload1/A _1806_/DE _1805_/Q _1805_/D VPWR VGND sky130_fd_sc_hd__edfxtp_1
X_1736_ VPWR VGND _1788_/CLK _1737_/DE _1736_/Q _1736_/D VPWR VGND sky130_fd_sc_hd__edfxtp_1
X_1667_ VPWR VGND VGND VPWR _1693_/A _1667_/Y sky130_fd_sc_hd__inv_1
X_1598_ VGND VPWR VPWR VGND _1807_/D _1598_/B _1843_/Q sky130_fd_sc_hd__and2_0
XFILLER_41_315 VPWR VGND VPWR VGND sky130_fd_sc_hd__decap_3
XFILLER_38_183 VGND VPWR VPWR VGND sky130_fd_sc_hd__decap_12
XFILLER_44_197 VGND VPWR VPWR VGND sky130_fd_sc_hd__decap_4
XFILLER_44_153 VPWR VGND VPWR VGND sky130_fd_sc_hd__decap_8
Xoutput307 VPWR VGND dbg_pc[2] _2019_/X VPWR VGND sky130_fd_sc_hd__buf_4
Xoutput318 VPWR VGND mem_addr[1] _1252_/X VPWR VGND sky130_fd_sc_hd__buf_4
X_1521_ VPWR VGND VGND VPWR _1937_/Q _1522_/B _2018_/A _1521_/S sky130_fd_sc_hd__mux2i_1
X_1452_ VGND VPWR VGND VPWR _1883_/Q _1889_/Q _1455_/B _1884_/Q _1874_/Q sky130_fd_sc_hd__nor4_2
Xoutput329 VPWR VGND mem_wdata[11] _2040_/X VPWR VGND sky130_fd_sc_hd__buf_4
X_1383_ VGND VPWR VPWR VGND _1764_/D _1386_/B _1848_/Q sky130_fd_sc_hd__and2_0
X_2004_ VPWR VGND _2008_/CLK _2008_/DE _2004_/Q _2004_/D VPWR VGND sky130_fd_sc_hd__edfxtp_1
X_1719_ VPWR VGND _2009_/CLK _1724_/DE _1719_/Q _1719_/D VPWR VGND sky130_fd_sc_hd__edfxtp_1
XFILLER_58_201 VGND VPWR VPWR VGND sky130_fd_sc_hd__decap_12
XFILLER_26_197 VGND VPWR VPWR VGND sky130_fd_sc_hd__decap_12
XFILLER_26_131 VPWR VGND VPWR VGND sky130_fd_sc_hd__decap_8
XFILLER_66_50 VPWR VGND VPWR VGND sky130_fd_sc_hd__decap_6
XFILLER_49_289 VGND VPWR VPWR VGND sky130_fd_sc_hd__decap_4
XFILLER_60_421 VGND VPWR VPWR VGND sky130_fd_sc_hd__decap_4
X_0952_ VGND VPWR VPWR VGND _1928_/Q _0952_/Y _0950_/X _0974_/A _0937_/Y _0951_/Y
+ sky130_fd_sc_hd__a32oi_1
XFILLER_32_189 VPWR VGND VPWR VGND sky130_fd_sc_hd__decap_6
X_1504_ VPWR VGND VGND VPWR _1680_/A _1504_/B _1946_/D sky130_fd_sc_hd__nor2_1
XFILLER_63_3 VGND VPWR VPWR VGND sky130_fd_sc_hd__decap_12
X_0883_ VGND VPWR _0883_/B _0898_/B _0883_/A VPWR VGND sky130_fd_sc_hd__xnor2_1
XFILLER_9_385 VPWR VGND VPWR VGND sky130_fd_sc_hd__decap_6
X_1366_ VPWR VGND VPWR VGND _1889_/Q _1997_/Q _1366_/B1 _1366_/Y sky130_fd_sc_hd__a21oi_1
X_1435_ VGND VPWR VPWR VGND _1708_/D _1448_/B _1856_/Q sky130_fd_sc_hd__and2_0
XFILLER_63_281 VGND VPWR VPWR VGND sky130_fd_sc_hd__decap_4
XFILLER_55_259 VPWR VGND VPWR VGND sky130_fd_sc_hd__decap_6
X_1297_ VGND VPWR _1890_/Q _1297_/Y _1957_/Q VPWR VGND sky130_fd_sc_hd__xnor2_1
Xplace270 VPWR VGND _1261_/S0 _1828_/Q VPWR VGND sky130_fd_sc_hd__buf_2
Xplace281 VPWR VGND _1083_/S1 _1824_/Q VPWR VGND sky130_fd_sc_hd__buf_2
XFILLER_52_85 VGND VPWR VPWR VGND sky130_fd_sc_hd__decap_12
XFILLER_42_421 VGND VPWR VPWR VGND sky130_fd_sc_hd__decap_4
XFILLER_6_333 VGND VPWR VPWR VGND sky130_fd_sc_hd__decap_12
XFILLER_6_377 VGND VPWR VPWR VGND sky130_fd_sc_hd__decap_12
X_1151_ VPWR VGND VGND VPWR _1937_/Q _1151_/Y _1219_/A sky130_fd_sc_hd__nand2_1
X_1220_ VGND VPWR VGND VPWR _1216_/Y _1218_/Y _1860_/D _1219_/Y sky130_fd_sc_hd__o21ai_0
XFILLER_45_281 VPWR VGND VPWR VGND sky130_fd_sc_hd__decap_6
XFILLER_37_237 VGND VPWR VPWR VGND sky130_fd_sc_hd__decap_12
XFILLER_33_421 VGND VPWR VPWR VGND sky130_fd_sc_hd__decap_4
X_1082_ VGND VPWR VGND VPWR _1083_/S0 _1711_/Q _1695_/Q _1083_/S1 _1727_/Q _1743_/Q
+ _1082_/X sky130_fd_sc_hd__mux4_2
XFILLER_60_262 VGND VPWR VPWR VGND sky130_fd_sc_hd__decap_12
X_0935_ VPWR VGND VGND VPWR _1839_/Q _0958_/B _0957_/B sky130_fd_sc_hd__nand2_1
X_1984_ VPWR VGND _1984_/CLK _1682_/Y _1984_/Q _1984_/D VPWR VGND sky130_fd_sc_hd__edfxtp_1
X_0866_ VPWR VGND VGND VPWR _1995_/Q _0866_/B _0880_/B sky130_fd_sc_hd__nor2_1
XPHY_EDGE_ROW_21_Left_93 VPWR VGND VPWR VGND sky130_fd_sc_hd__decap_3
X_1349_ VGND VPWR VPWR VGND _1858_/D _1584_/A1 _1349_/S _1993_/Q sky130_fd_sc_hd__mux2_1
X_1418_ VGND VPWR VPWR VGND _1727_/D _1418_/B _1843_/Q sky130_fd_sc_hd__and2_0
XFILLER_24_421 VGND VPWR VPWR VGND sky130_fd_sc_hd__decap_4
XFILLER_59_340 VGND VPWR VPWR VGND sky130_fd_sc_hd__decap_12
XFILLER_34_207 VPWR VGND VPWR VGND sky130_fd_sc_hd__decap_8
XFILLER_27_281 VGND VPWR VPWR VGND sky130_fd_sc_hd__decap_4
XFILLER_19_237 VPWR VGND VPWR VGND sky130_fd_sc_hd__decap_8
XFILLER_8_79 VGND VPWR VPWR VGND sky130_fd_sc_hd__decap_4
XFILLER_6_185 VPWR VGND VPWR VGND sky130_fd_sc_hd__decap_3
X_1203_ VPWR VGND VGND VPWR _1203_/A _1203_/B _1205_/A _1203_/C sky130_fd_sc_hd__nand3_1
X_1134_ VPWR VGND VGND VPWR _1884_/D _1134_/Y _1221_/B sky130_fd_sc_hd__nand2_1
XFILLER_26_3 VGND VPWR VPWR VGND sky130_fd_sc_hd__decap_12
X_1065_ VPWR VGND VGND VPWR _1064_/X _1065_/Y _1063_/X _1084_/S sky130_fd_sc_hd__mux2i_1
XFILLER_18_281 VPWR VGND VPWR VGND sky130_fd_sc_hd__decap_8
X_1967_ _2019_/A _1967_/CLK _1967_/D VPWR VGND VPWR VGND sky130_fd_sc_hd__dfxtp_1
X_0918_ VGND VPWR _0918_/B _1361_/C _1933_/Q VPWR VGND sky130_fd_sc_hd__xnor2_1
X_0849_ VPWR VGND VGND VPWR _1891_/Q _1270_/B sky130_fd_sc_hd__inv_1
X_1898_ VPWR VGND _2006_/CLK _1642_/Y _2033_/A _1898_/D VPWR VGND sky130_fd_sc_hd__edfxtp_1
XFILLER_68_29 VGND VPWR VPWR VGND sky130_fd_sc_hd__decap_12
XFILLER_68_170 VPWR VGND VPWR VGND sky130_fd_sc_hd__decap_6
XFILLER_56_365 VGND VPWR VPWR VGND sky130_fd_sc_hd__decap_4
XFILLER_17_33 VGND VPWR VPWR VGND sky130_fd_sc_hd__decap_12
XFILLER_33_76 VGND VPWR VPWR VGND sky130_fd_sc_hd__decap_12
XFILLER_33_65 VPWR VGND VPWR VGND sky130_fd_sc_hd__decap_6
XFILLER_12_413 VPWR VGND VPWR VGND sky130_fd_sc_hd__decap_3
XFILLER_58_73 VPWR VGND VPWR VGND sky130_fd_sc_hd__decap_8
XFILLER_58_62 VPWR VGND VPWR VGND sky130_fd_sc_hd__decap_8
X_1683_ VPWR VGND VGND VPWR _1688_/A _1683_/Y sky130_fd_sc_hd__inv_1
Xhold406 _1551_/A _1868_/Q VPWR VGND VGND VPWR sky130_fd_sc_hd__dlygate4sd3_1
Xclkbuf_leaf_10_clk _1994_/CLK clkbuf_leaf_4_clk/A VPWR VGND VGND VPWR sky130_fd_sc_hd__clkbuf_8
XFILLER_30_287 VGND VPWR VPWR VGND sky130_fd_sc_hd__decap_4
X_1752_ VPWR VGND _1788_/CLK _1758_/DE _1752_/Q _1752_/D VPWR VGND sky130_fd_sc_hd__edfxtp_1
X_1821_ VPWR VGND _2009_/CLK _1266_/X _1821_/Q _1821_/D VPWR VGND sky130_fd_sc_hd__edfxtp_1
XFILLER_53_357 VPWR VGND VPWR VGND sky130_fd_sc_hd__decap_3
XFILLER_38_365 VPWR VGND VPWR VGND sky130_fd_sc_hd__decap_3
X_1117_ VGND VPWR VGND VPWR _1127_/S0 _1731_/Q _1699_/Q _1127_/S1 _1763_/Q _1795_/Q
+ _1117_/X sky130_fd_sc_hd__mux4_2
XPHY_EDGE_ROW_3_Right_3 VPWR VGND VPWR VGND sky130_fd_sc_hd__decap_3
X_1048_ VGND VPWR VGND VPWR _1083_/S0 _1718_/Q _1702_/Q _1083_/S1 _1734_/Q _1750_/Q
+ _1048_/X sky130_fd_sc_hd__mux4_2
XFILLER_21_287 VGND VPWR VPWR VGND sky130_fd_sc_hd__decap_12
XFILLER_0_125 VPWR VGND VPWR VGND sky130_fd_sc_hd__decap_8
XFILLER_0_169 VGND VPWR VPWR VGND sky130_fd_sc_hd__decap_12
XFILLER_71_187 VPWR VGND VPWR VGND sky130_fd_sc_hd__decap_3
XFILLER_71_165 VPWR VGND VPWR VGND sky130_fd_sc_hd__decap_3
XFILLER_71_121 VPWR VGND VPWR VGND sky130_fd_sc_hd__decap_3
XFILLER_44_357 VPWR VGND VPWR VGND sky130_fd_sc_hd__decap_6
XFILLER_29_365 VPWR VGND VPWR VGND sky130_fd_sc_hd__decap_3
XFILLER_60_85 VGND VPWR VPWR VGND sky130_fd_sc_hd__decap_4
XFILLER_44_97 VPWR VGND VPWR VGND sky130_fd_sc_hd__decap_8
XFILLER_67_405 VGND VPWR VPWR VGND sky130_fd_sc_hd__decap_12
XFILLER_39_107 VGND VPWR VPWR VGND sky130_fd_sc_hd__decap_4
X_2020_ VPWR VGND _2020_/X _2020_/A VPWR VGND sky130_fd_sc_hd__buf_2
X_1666_ VPWR VGND VGND VPWR _1671_/A _1666_/Y sky130_fd_sc_hd__inv_1
X_1735_ VPWR VGND _2015_/CLK _1742_/DE _1735_/Q _1735_/D VPWR VGND sky130_fd_sc_hd__edfxtp_1
X_1804_ VPWR VGND _2016_/CLK _1806_/DE _1804_/Q _1804_/D VPWR VGND sky130_fd_sc_hd__edfxtp_1
X_1597_ VGND VPWR VPWR VGND _1808_/D _1598_/B _1844_/Q sky130_fd_sc_hd__and2_0
XFILLER_41_349 VGND VPWR VPWR VGND sky130_fd_sc_hd__decap_12
XFILLER_26_357 VPWR VGND VPWR VGND sky130_fd_sc_hd__decap_6
Xoutput308 VPWR VGND dbg_pc[3] _2020_/X VPWR VGND sky130_fd_sc_hd__buf_4
Xoutput319 VPWR VGND mem_addr[2] _1251_/X VPWR VGND sky130_fd_sc_hd__buf_4
X_1520_ VPWR VGND VGND VPWR _1522_/A _1520_/B _1938_/D sky130_fd_sc_hd__nor2_1
XFILLER_67_213 VPWR VGND VPWR VGND sky130_fd_sc_hd__decap_8
X_1451_ VPWR VGND VGND VPWR _1451_/C _1876_/Q _1877_/Q _1455_/A sky130_fd_sc_hd__nor3_1
X_1382_ VGND VPWR VPWR VGND _1765_/D _1386_/B _1849_/Q sky130_fd_sc_hd__and2_0
XFILLER_35_121 VPWR VGND VPWR VGND sky130_fd_sc_hd__decap_3
X_2003_ VPWR VGND _2008_/CLK _2008_/DE _2003_/Q _2003_/D VPWR VGND sky130_fd_sc_hd__edfxtp_1
XFILLER_50_146 VGND VPWR VPWR VGND sky130_fd_sc_hd__decap_12
XFILLER_31_393 VPWR VGND VPWR VGND sky130_fd_sc_hd__decap_3
X_1649_ VPWR VGND VGND VPWR _1691_/A _1649_/Y sky130_fd_sc_hd__inv_1
X_1718_ VPWR VGND _1807_/CLK _1724_/DE _1718_/Q _1718_/D VPWR VGND sky130_fd_sc_hd__edfxtp_1
XFILLER_58_213 VPWR VGND VPWR VGND sky130_fd_sc_hd__decap_6
XFILLER_41_146 VPWR VGND VPWR VGND sky130_fd_sc_hd__decap_8
XFILLER_41_113 VPWR VGND VPWR VGND sky130_fd_sc_hd__decap_8
XFILLER_2_15 VGND VPWR VPWR VGND sky130_fd_sc_hd__decap_12
X_0951_ VPWR VGND VGND VPWR _1840_/Q _0958_/B _0951_/Y sky130_fd_sc_hd__nand2b_1
X_0882_ VGND VPWR VPWR VGND _1924_/Q _0900_/B _0882_/B sky130_fd_sc_hd__xor2_1
XFILLER_13_393 VGND VPWR VPWR VGND sky130_fd_sc_hd__decap_12
X_1503_ VPWR VGND VGND VPWR _1946_/Q _1504_/B _2027_/A _1606_/C sky130_fd_sc_hd__mux2i_1
XFILLER_56_3 VPWR VGND VPWR VGND sky130_fd_sc_hd__decap_6
X_1296_ VPWR VGND VPWR VGND _1892_/Q _0835_/Y _1317_/A _1296_/Y sky130_fd_sc_hd__a21oi_1
X_1365_ VGND VPWR _1365_/B _1365_/Y _1365_/A VPWR VGND sky130_fd_sc_hd__xnor2_1
X_1434_ VGND VPWR VPWR VGND _1709_/D _1525_/B _1857_/Q sky130_fd_sc_hd__and2_0
Xplace260 VPWR VGND _1353_/B _1962_/Q VPWR VGND sky130_fd_sc_hd__buf_2
Xplace282 VPWR VGND _1286_/S0 _1059_/S0 VPWR VGND sky130_fd_sc_hd__buf_4
Xplace271 VPWR VGND _1127_/S1 _1130_/S1 VPWR VGND sky130_fd_sc_hd__buf_2
XFILLER_23_113 VPWR VGND VPWR VGND sky130_fd_sc_hd__decap_8
XFILLER_36_76 VPWR VGND VPWR VGND sky130_fd_sc_hd__decap_8
XFILLER_36_65 VPWR VGND VPWR VGND sky130_fd_sc_hd__decap_6
XFILLER_54_293 VGND VPWR VPWR VGND sky130_fd_sc_hd__decap_12
XFILLER_42_9 VGND VPWR VPWR VGND sky130_fd_sc_hd__decap_4
XFILLER_6_345 VGND VPWR VPWR VGND sky130_fd_sc_hd__decap_12
XFILLER_6_389 VGND VPWR VPWR VGND sky130_fd_sc_hd__decap_12
X_1150_ VPWR VGND VGND VPWR _1939_/Q _1203_/B _1209_/B sky130_fd_sc_hd__nand2_1
X_1081_ VGND VPWR VGND VPWR _1077_/Y _1086_/A1 _1920_/D _1080_/Y sky130_fd_sc_hd__o21ai_0
XFILLER_37_249 VPWR VGND VPWR VGND sky130_fd_sc_hd__decap_8
XFILLER_20_105 VPWR VGND VPWR VGND sky130_fd_sc_hd__decap_6
X_1983_ VPWR VGND _1983_/CLK _1683_/Y _1983_/Q _1983_/D VPWR VGND sky130_fd_sc_hd__edfxtp_1
X_0934_ VPWR VGND VGND VPWR _0934_/B _0957_/B _0934_/A sky130_fd_sc_hd__nor2_2
X_0865_ VGND VPWR VPWR VGND _0881_/B _0863_/B _1924_/Q _1923_/Q _0875_/A sky130_fd_sc_hd__o31ai_2
XFILLER_20_149 VPWR VGND VPWR VGND sky130_fd_sc_hd__decap_6
X_1417_ VGND VPWR VPWR VGND _1728_/D _1418_/B _1844_/Q sky130_fd_sc_hd__and2_0
X_1348_ VPWR VGND VGND VPWR _1885_/D _1207_/B _1347_/Y _1870_/D sky130_fd_sc_hd__o21a_1
X_1279_ VPWR VGND VGND VPWR _1281_/A _1283_/B _1279_/Y sky130_fd_sc_hd__nor2_1
XFILLER_28_249 VPWR VGND VPWR VGND sky130_fd_sc_hd__decap_3
XFILLER_22_34 VGND VPWR VPWR VGND sky130_fd_sc_hd__decap_12
XFILLER_3_337 VGND VPWR VPWR VGND sky130_fd_sc_hd__decap_12
XFILLER_30_403 VGND VPWR VPWR VGND sky130_fd_sc_hd__decap_12
XFILLER_6_131 VPWR VGND VPWR VGND sky130_fd_sc_hd__decap_8
XFILLER_6_197 VGND VPWR VPWR VGND sky130_fd_sc_hd__decap_12
X_1202_ VGND VPWR VGND VPWR _1201_/Y _1199_/Y _1864_/D _1200_/Y sky130_fd_sc_hd__o21ai_0
X_1133_ VPWR VGND VGND VPWR _1207_/B _1133_/A _1133_/B sky130_fd_sc_hd__nand2_2
X_1064_ VGND VPWR VGND VPWR _1073_/S0 _1779_/Q _1763_/Q _1064_/S1 _1795_/Q _1811_/Q
+ _1064_/X sky130_fd_sc_hd__mux4_2
XFILLER_19_3 VGND VPWR VPWR VGND sky130_fd_sc_hd__decap_12
X_1966_ _2018_/A _1969_/CLK _1966_/D VPWR VGND VPWR VGND sky130_fd_sc_hd__dfxtp_1
X_0848_ VPWR VGND VGND VPWR _1860_/Q _0848_/Y sky130_fd_sc_hd__inv_1
X_0917_ VPWR VGND VPWR VGND _0872_/B _0872_/A _1995_/Q _0918_/B sky130_fd_sc_hd__a21oi_1
X_1897_ VPWR VGND _2008_/CLK _1643_/Y _2032_/A _1897_/D VPWR VGND sky130_fd_sc_hd__edfxtp_1
XFILLER_71_325 VPWR VGND VPWR VGND sky130_fd_sc_hd__decap_8
XFILLER_56_377 VPWR VGND VPWR VGND sky130_fd_sc_hd__decap_6
XFILLER_17_45 VPWR VGND VPWR VGND sky130_fd_sc_hd__decap_8
XPHY_EDGE_ROW_49_Left_121 VPWR VGND VPWR VGND sky130_fd_sc_hd__decap_3
XPHY_EDGE_ROW_58_Left_130 VPWR VGND VPWR VGND sky130_fd_sc_hd__decap_3
XFILLER_47_388 VGND VPWR VPWR VGND sky130_fd_sc_hd__decap_4
X_1820_ VPWR VGND clkload6/A _1822_/DE _1820_/Q _1820_/D VPWR VGND sky130_fd_sc_hd__edfxtp_1
X_1682_ VPWR VGND VGND VPWR _1682_/A _1682_/Y sky130_fd_sc_hd__inv_1
Xhold407 _1873_/D _1917_/Q VPWR VGND VGND VPWR sky130_fd_sc_hd__dlygate4sd3_1
X_1751_ VPWR VGND clkload1/A _1758_/DE _1751_/Q _1751_/D VPWR VGND sky130_fd_sc_hd__edfxtp_1
X_1047_ VPWR VGND VGND VPWR _1307_/A _1047_/Y _1085_/B sky130_fd_sc_hd__nand2_1
X_1116_ VGND VPWR VPWR VGND _1879_/D _1114_/X _1131_/S _1115_/X sky130_fd_sc_hd__mux2_1
XFILLER_0_81 VPWR VGND VPWR VGND sky130_fd_sc_hd__decap_3
X_1949_ _1949_/Q _1979_/CLK _1949_/D VPWR VGND VPWR VGND sky130_fd_sc_hd__dfxtp_1
XFILLER_44_347 VPWR VGND VPWR VGND sky130_fd_sc_hd__decap_3
XFILLER_44_325 VPWR VGND VPWR VGND sky130_fd_sc_hd__decap_6
XFILLER_44_76 VPWR VGND VPWR VGND sky130_fd_sc_hd__decap_8
XFILLER_44_21 VPWR VGND VPWR VGND sky130_fd_sc_hd__decap_6
XFILLER_5_15 VGND VPWR VPWR VGND sky130_fd_sc_hd__decap_12
XFILLER_4_421 VGND VPWR VPWR VGND sky130_fd_sc_hd__decap_4
XFILLER_69_51 VGND VPWR VPWR VGND sky130_fd_sc_hd__decap_4
XFILLER_67_417 VPWR VGND VPWR VGND sky130_fd_sc_hd__decap_3
XPHY_EDGE_ROW_13_Right_13 VPWR VGND VPWR VGND sky130_fd_sc_hd__decap_3
X_1803_ VPWR VGND _2016_/CLK _1806_/DE _1803_/Q _1803_/D VPWR VGND sky130_fd_sc_hd__edfxtp_1
XPHY_EDGE_ROW_22_Right_22 VPWR VGND VPWR VGND sky130_fd_sc_hd__decap_3
X_1665_ VPWR VGND VGND VPWR _1686_/A _1665_/Y sky130_fd_sc_hd__inv_1
XFILLER_7_281 VGND VPWR VPWR VGND sky130_fd_sc_hd__decap_12
X_1596_ VGND VPWR VPWR VGND _1809_/D _1598_/B _1845_/Q sky130_fd_sc_hd__and2_0
X_1734_ VPWR VGND _1749_/CLK _1737_/DE _1734_/Q _1734_/D VPWR VGND sky130_fd_sc_hd__edfxtp_1
XFILLER_38_141 VGND VPWR VPWR VGND sky130_fd_sc_hd__decap_4
XFILLER_38_130 VPWR VGND VPWR VGND sky130_fd_sc_hd__decap_8
XPHY_EDGE_ROW_31_Right_31 VPWR VGND VPWR VGND sky130_fd_sc_hd__decap_3
XPHY_EDGE_ROW_40_Right_40 VPWR VGND VPWR VGND sky130_fd_sc_hd__decap_3
XFILLER_5_218 VPWR VGND VPWR VGND sky130_fd_sc_hd__decap_6
XFILLER_44_133 VPWR VGND VPWR VGND sky130_fd_sc_hd__decap_6
XFILLER_71_85 VGND VPWR VPWR VGND sky130_fd_sc_hd__decap_12
XFILLER_71_41 VGND VPWR VPWR VGND sky130_fd_sc_hd__decap_12
XFILLER_44_188 VPWR VGND VPWR VGND sky130_fd_sc_hd__decap_8
Xoutput309 VPWR VGND dbg_pc[4] _2021_/X VPWR VGND sky130_fd_sc_hd__buf_4
X_1450_ VPWR VGND VPWR VGND _1886_/Q _1875_/Q _1880_/Q _1887_/Q _1451_/C sky130_fd_sc_hd__or4_1
XFILLER_67_225 VGND VPWR VPWR VGND sky130_fd_sc_hd__decap_4
X_1381_ VGND VPWR VPWR VGND _1766_/D _1529_/B _1850_/Q sky130_fd_sc_hd__and2_0
X_2002_ VPWR VGND _2008_/CLK _2008_/DE _2002_/Q _2002_/D VPWR VGND sky130_fd_sc_hd__edfxtp_1
XFILLER_50_169 VPWR VGND VPWR VGND sky130_fd_sc_hd__decap_8
X_1579_ VPWR VGND VPWR VGND _1576_/Y _1573_/A _1578_/Y _1968_/D sky130_fd_sc_hd__a21oi_1
X_1648_ VPWR VGND VGND VPWR _1691_/A _1648_/Y sky130_fd_sc_hd__inv_1
X_1717_ VPWR VGND _1749_/CLK _1726_/DE _1717_/Q _1717_/D VPWR VGND sky130_fd_sc_hd__edfxtp_1
XFILLER_26_188 VPWR VGND VPWR VGND sky130_fd_sc_hd__decap_8
XFILLER_22_361 VPWR VGND VPWR VGND sky130_fd_sc_hd__decap_3
XFILLER_41_88 VGND VPWR VPWR VGND sky130_fd_sc_hd__decap_12
XFILLER_49_225 VPWR VGND VPWR VGND sky130_fd_sc_hd__decap_8
XFILLER_66_85 VGND VPWR VPWR VGND sky130_fd_sc_hd__decap_12
XFILLER_32_147 VGND VPWR VPWR VGND sky130_fd_sc_hd__decap_12
XFILLER_32_125 VGND VPWR VPWR VGND sky130_fd_sc_hd__decap_12
X_0950_ VPWR VGND VPWR VGND _1883_/Q _0997_/A _0998_/A1 _0950_/X sky130_fd_sc_hd__a21o_1
X_0881_ VGND VPWR VPWR VGND _1925_/Q _0902_/B _0881_/B sky130_fd_sc_hd__xor2_1
XFILLER_20_309 VGND VPWR VPWR VGND sky130_fd_sc_hd__decap_12
X_1502_ VPWR VGND VGND VPWR _1688_/A _1502_/B _1948_/D sky130_fd_sc_hd__nor2_1
XFILLER_49_3 VPWR VGND VPWR VGND sky130_fd_sc_hd__decap_8
X_1433_ VGND VPWR VPWR VGND _1711_/D _1433_/B _1843_/Q sky130_fd_sc_hd__and2_0
X_1295_ VPWR VGND VPWR VGND _1270_/B _1958_/Q _1294_/Y _1295_/Y sky130_fd_sc_hd__a21oi_1
X_1364_ VGND VPWR _1364_/B _1365_/B _1364_/A VPWR VGND sky130_fd_sc_hd__xnor2_1
Xplace250 VPWR VGND _1283_/A _1267_/Y VPWR VGND sky130_fd_sc_hd__buf_2
Xplace261 VPWR VGND _1140_/B _1956_/Q VPWR VGND sky130_fd_sc_hd__buf_2
XFILLER_51_401 VPWR VGND VPWR VGND sky130_fd_sc_hd__decap_3
Xplace272 VPWR VGND _1130_/S1 _1828_/Q VPWR VGND sky130_fd_sc_hd__buf_2
Xplace283 VPWR VGND _1059_/S0 _1073_/S0 VPWR VGND sky130_fd_sc_hd__buf_2
XFILLER_23_169 VPWR VGND VPWR VGND sky130_fd_sc_hd__decap_8
XFILLER_11_25 VGND VPWR VPWR VGND sky130_fd_sc_hd__decap_12
XFILLER_61_209 VPWR VGND VPWR VGND sky130_fd_sc_hd__decap_8
XFILLER_54_261 VGND VPWR VPWR VGND sky130_fd_sc_hd__decap_12
XPHY_EDGE_ROW_30_Left_102 VPWR VGND VPWR VGND sky130_fd_sc_hd__decap_3
XFILLER_14_169 VGND VPWR VPWR VGND sky130_fd_sc_hd__decap_12
XFILLER_69_309 VPWR VGND VPWR VGND sky130_fd_sc_hd__decap_6
XFILLER_6_357 VPWR VGND VPWR VGND sky130_fd_sc_hd__decap_6
X_1080_ VPWR VGND VGND VPWR _1079_/X _1080_/Y _1078_/X _1084_/S sky130_fd_sc_hd__mux2i_1
XFILLER_60_242 VPWR VGND VPWR VGND sky130_fd_sc_hd__decap_6
XFILLER_52_209 VGND VPWR VPWR VGND sky130_fd_sc_hd__decap_4
X_1982_ VPWR VGND _1982_/CLK _1684_/Y _1982_/Q _1982_/D VPWR VGND sky130_fd_sc_hd__edfxtp_1
XFILLER_45_250 VPWR VGND VPWR VGND sky130_fd_sc_hd__decap_3
X_0933_ VPWR VGND VGND VPWR _1836_/Q _1837_/Q _0934_/B _0973_/B sky130_fd_sc_hd__nand3_1
X_0864_ VGND VPWR VGND VPWR _0875_/A _1923_/Q _0882_/B _0863_/B sky130_fd_sc_hd__o21ai_0
X_1347_ VGND VPWR VGND VPWR _1346_/Y _1218_/A _1347_/Y _1345_/X sky130_fd_sc_hd__o21ai_0
XFILLER_3_81 VGND VPWR VPWR VGND sky130_fd_sc_hd__decap_12
X_1416_ VGND VPWR VPWR VGND _1729_/D _1418_/B _1845_/Q sky130_fd_sc_hd__and2_0
X_1278_ VPWR VGND VGND VPWR _1892_/Q _1891_/Q _1283_/B sky130_fd_sc_hd__nand2b_1
XFILLER_22_46 VGND VPWR VPWR VGND sky130_fd_sc_hd__decap_12
XFILLER_3_349 VGND VPWR VPWR VGND sky130_fd_sc_hd__decap_12
XFILLER_3_305 VGND VPWR VPWR VGND sky130_fd_sc_hd__decap_12
XFILLER_47_65 VPWR VGND VPWR VGND sky130_fd_sc_hd__decap_3
XPHY_EDGE_ROW_69_Right_69 VPWR VGND VPWR VGND sky130_fd_sc_hd__decap_3
XFILLER_27_261 VGND VPWR VPWR VGND sky130_fd_sc_hd__decap_12
XFILLER_8_15 VGND VPWR VPWR VGND sky130_fd_sc_hd__decap_12
XFILLER_15_401 VGND VPWR VPWR VGND sky130_fd_sc_hd__decap_12
XFILLER_6_165 VGND VPWR VPWR VGND sky130_fd_sc_hd__decap_12
X_1201_ VPWR VGND VGND VPWR _1879_/D _1201_/Y _1221_/B sky130_fd_sc_hd__nand2_1
X_1132_ VPWR VGND _1305_/B _1133_/B _1133_/A VPWR VGND sky130_fd_sc_hd__and2_1
X_1063_ VGND VPWR VGND VPWR _1073_/S0 _1715_/Q _1699_/Q _1824_/Q _1731_/Q _1747_/Q
+ _1063_/X sky130_fd_sc_hd__mux4_2
X_1965_ _2017_/A _1984_/CLK _1965_/D VPWR VGND VPWR VGND sky130_fd_sc_hd__dfxtp_2
X_0916_ VPWR VGND VGND VPWR _1361_/B _0923_/A _1887_/Q _0916_/B sky130_fd_sc_hd__maj3_1
X_0847_ VPWR VGND VGND VPWR _1862_/Q _0847_/Y sky130_fd_sc_hd__inv_1
X_1896_ VPWR VGND _2007_/CLK _1644_/Y _2031_/A _1896_/D VPWR VGND sky130_fd_sc_hd__edfxtp_1
XFILLER_56_301 VPWR VGND VPWR VGND sky130_fd_sc_hd__decap_6
XFILLER_71_315 VGND VPWR VPWR VGND sky130_fd_sc_hd__decap_4
XFILLER_58_20 VGND VPWR VPWR VGND sky130_fd_sc_hd__decap_4
XFILLER_3_113 VGND VPWR VPWR VGND sky130_fd_sc_hd__decap_12
XFILLER_62_337 VGND VPWR VPWR VGND sky130_fd_sc_hd__decap_12
XFILLER_70_370 VGND VPWR VPWR VGND sky130_fd_sc_hd__decap_12
X_1750_ VPWR VGND _1807_/CLK _1758_/DE _1750_/Q _1750_/D VPWR VGND sky130_fd_sc_hd__edfxtp_1
Xhold408 _1832_/D _1937_/Q VPWR VGND VGND VPWR sky130_fd_sc_hd__dlygate4sd3_1
X_1681_ VPWR VGND VGND VPWR _1682_/A _1681_/Y sky130_fd_sc_hd__inv_1
X_1046_ VGND VPWR VGND VPWR _1353_/B _1963_/Q _1085_/B _1961_/Q sky130_fd_sc_hd__a21oi_4
XFILLER_38_389 VPWR VGND VPWR VGND sky130_fd_sc_hd__decap_8
X_1115_ VGND VPWR VGND VPWR _1130_/S0 _1748_/Q _1716_/Q _1130_/S1 _1780_/Q _1812_/Q
+ _1115_/X sky130_fd_sc_hd__mux4_2
X_1948_ _1948_/Q _1983_/CLK _1948_/D VPWR VGND VPWR VGND sky130_fd_sc_hd__dfxtp_1
X_1879_ VPWR VGND _1987_/CLK _1925_/DE _1879_/Q _1879_/D VPWR VGND sky130_fd_sc_hd__edfxtp_1
XFILLER_56_197 VPWR VGND VPWR VGND sky130_fd_sc_hd__decap_6
XFILLER_5_27 VGND VPWR VPWR VGND sky130_fd_sc_hd__decap_12
XFILLER_8_249 VPWR VGND VPWR VGND sky130_fd_sc_hd__decap_3
XFILLER_62_178 VGND VPWR VPWR VGND sky130_fd_sc_hd__decap_12
XFILLER_47_164 VGND VPWR VPWR VGND sky130_fd_sc_hd__decap_4
X_1802_ VPWR VGND _2015_/CLK _1806_/DE _1802_/Q _1802_/D VPWR VGND sky130_fd_sc_hd__edfxtp_1
X_1733_ VPWR VGND clkload4/A _1737_/DE _1733_/Q _1733_/D VPWR VGND sky130_fd_sc_hd__edfxtp_1
X_1664_ VPWR VGND VGND VPWR _1686_/A _1664_/Y sky130_fd_sc_hd__inv_1
XFILLER_7_293 VGND VPWR VPWR VGND sky130_fd_sc_hd__decap_12
X_1595_ VGND VPWR VPWR VGND _1810_/D _1598_/B _1846_/Q sky130_fd_sc_hd__and2_0
X_1029_ VGND VPWR VGND VPWR _1288_/B1 _1288_/A1 _1931_/D _1028_/Y sky130_fd_sc_hd__o21ai_0
XFILLER_30_79 VGND VPWR VPWR VGND sky130_fd_sc_hd__decap_4
XFILLER_30_35 VGND VPWR VPWR VGND sky130_fd_sc_hd__decap_12
XFILLER_29_131 VPWR VGND VPWR VGND sky130_fd_sc_hd__decap_6
XFILLER_17_337 VGND VPWR VPWR VGND sky130_fd_sc_hd__decap_12
XFILLER_71_97 VGND VPWR VPWR VGND sky130_fd_sc_hd__decap_12
XFILLER_71_53 VPWR VGND VPWR VGND sky130_fd_sc_hd__decap_3
XFILLER_40_384 VPWR VGND VPWR VGND sky130_fd_sc_hd__decap_3
X_1380_ VGND VPWR VPWR VGND _1767_/D _1386_/B _1851_/Q sky130_fd_sc_hd__and2_0
X_2001_ VPWR VGND _2001_/CLK _2016_/DE _2001_/Q _2001_/D VPWR VGND sky130_fd_sc_hd__edfxtp_1
X_1716_ VPWR VGND _1993_/CLK _1726_/DE _1716_/Q _1716_/D VPWR VGND sky130_fd_sc_hd__edfxtp_1
XFILLER_31_384 VPWR VGND VPWR VGND sky130_fd_sc_hd__decap_8
X_1578_ VGND VPWR VGND VPWR _1577_/Y _2020_/A _1578_/Y _1553_/B sky130_fd_sc_hd__o21ai_0
X_1647_ VPWR VGND VGND VPWR _1647_/A _1647_/Y sky130_fd_sc_hd__inv_1
XFILLER_54_421 VGND VPWR VPWR VGND sky130_fd_sc_hd__decap_4
XFILLER_25_57 VGND VPWR VPWR VGND sky130_fd_sc_hd__decap_4
XFILLER_9_3 VGND VPWR VPWR VGND sky130_fd_sc_hd__decap_12
XFILLER_66_97 VGND VPWR VPWR VGND sky130_fd_sc_hd__decap_12
XFILLER_66_75 VPWR VGND VPWR VGND sky130_fd_sc_hd__decap_3
XFILLER_66_64 VGND VPWR VPWR VGND sky130_fd_sc_hd__decap_4
XFILLER_64_207 VPWR VGND VPWR VGND sky130_fd_sc_hd__decap_6
XFILLER_32_159 VPWR VGND VPWR VGND sky130_fd_sc_hd__decap_6
XFILLER_32_137 VPWR VGND VPWR VGND sky130_fd_sc_hd__decap_3
X_0880_ VGND VPWR _0880_/B _0904_/B _1926_/Q VPWR VGND sky130_fd_sc_hd__xnor2_1
X_1501_ VPWR VGND VGND VPWR _1357_/A _1502_/B _1501_/A1 _1565_/A sky130_fd_sc_hd__mux2i_1
X_1363_ VPWR VGND VPWR VGND _1933_/Q _0875_/A _0918_/B _1364_/B sky130_fd_sc_hd__a21oi_1
X_1432_ VGND VPWR VPWR VGND _1712_/D _1433_/B _1844_/Q sky130_fd_sc_hd__and2_0
X_1294_ VPWR VGND VGND VPWR _0835_/Y _1892_/Q _1270_/B _1958_/Q _1294_/Y sky130_fd_sc_hd__o22ai_1
XFILLER_36_421 VGND VPWR VPWR VGND sky130_fd_sc_hd__decap_4
Xplace251 VPWR VGND _1253_/S _1350_/S VPWR VGND sky130_fd_sc_hd__buf_2
Xplace262 VPWR VGND _1307_/A _1955_/Q VPWR VGND sky130_fd_sc_hd__buf_2
Xplace240 VPWR VGND _1770_/DE _1284_/Y VPWR VGND sky130_fd_sc_hd__buf_2
Xplace273 VPWR VGND _1261_/S1 _1827_/Q VPWR VGND sky130_fd_sc_hd__buf_4
Xplace284 VPWR VGND _1083_/S0 _1073_/S0 VPWR VGND sky130_fd_sc_hd__buf_4
XFILLER_11_15 VPWR VGND VPWR VGND sky130_fd_sc_hd__decap_6
XFILLER_11_37 VGND VPWR VPWR VGND sky130_fd_sc_hd__decap_12
XFILLER_54_273 VPWR VGND VPWR VGND sky130_fd_sc_hd__decap_3
XFILLER_39_281 VPWR VGND VPWR VGND sky130_fd_sc_hd__decap_6
XFILLER_52_77 VPWR VGND VPWR VGND sky130_fd_sc_hd__decap_6
XFILLER_52_66 VPWR VGND VPWR VGND sky130_fd_sc_hd__decap_8
XFILLER_10_343 VGND VPWR VPWR VGND sky130_fd_sc_hd__decap_12
XFILLER_10_365 VGND VPWR VPWR VGND sky130_fd_sc_hd__decap_12
XFILLER_45_262 VGND VPWR VPWR VGND sky130_fd_sc_hd__decap_12
XFILLER_18_421 VGND VPWR VPWR VGND sky130_fd_sc_hd__decap_4
XFILLER_60_298 VPWR VGND VPWR VGND sky130_fd_sc_hd__decap_8
XFILLER_60_221 VPWR VGND VPWR VGND sky130_fd_sc_hd__decap_3
X_0932_ VPWR VGND VGND VPWR _1836_/Q _0974_/B _0973_/B sky130_fd_sc_hd__nand2_1
X_1981_ VPWR VGND _1982_/CLK _1685_/Y _1981_/Q _1981_/D VPWR VGND sky130_fd_sc_hd__edfxtp_1
XFILLER_9_152 VPWR VGND VPWR VGND sky130_fd_sc_hd__decap_8
XFILLER_61_3 VPWR VGND VPWR VGND sky130_fd_sc_hd__decap_8
X_0863_ VPWR VGND VGND VPWR _0875_/A _0883_/B _0863_/B sky130_fd_sc_hd__nand2_1
X_1346_ VPWR VGND VPWR VGND _1218_/A _1959_/Q _1305_/B _1346_/Y sky130_fd_sc_hd__a21oi_1
XFILLER_3_93 VGND VPWR VPWR VGND sky130_fd_sc_hd__decap_12
X_1415_ VGND VPWR VPWR VGND _1730_/D _1418_/B _1846_/Q sky130_fd_sc_hd__and2_0
X_1277_ VGND VPWR VGND VPWR _1328_/B _1283_/A _1277_/Y _1281_/B sky130_fd_sc_hd__o21ai_0
XFILLER_24_413 VPWR VGND VPWR VGND sky130_fd_sc_hd__decap_3
Xclkbuf_leaf_31_clk _1749_/CLK clkbuf_3_4__f_clk/X VPWR VGND VGND VPWR sky130_fd_sc_hd__clkbuf_8
XFILLER_3_317 VGND VPWR VPWR VGND sky130_fd_sc_hd__decap_12
XFILLER_59_332 VGND VPWR VPWR VGND sky130_fd_sc_hd__decap_4
XFILLER_47_33 VPWR VGND VPWR VGND sky130_fd_sc_hd__decap_3
Xclkbuf_leaf_22_clk _1954_/CLK clkbuf_3_5__f_clk/X VPWR VGND VGND VPWR sky130_fd_sc_hd__clkbuf_8
XFILLER_27_273 VPWR VGND VPWR VGND sky130_fd_sc_hd__decap_6
XFILLER_15_413 VGND VPWR VPWR VGND sky130_fd_sc_hd__decap_12
XFILLER_6_177 VPWR VGND VPWR VGND sky130_fd_sc_hd__decap_8
X_1200_ VGND VPWR VGND VPWR _1207_/B _1953_/Q _1200_/Y _1222_/C sky130_fd_sc_hd__o21ai_0
XFILLER_65_346 VGND VPWR VPWR VGND sky130_fd_sc_hd__decap_12
X_1062_ VPWR VGND VGND VPWR _1952_/Q _1062_/Y _1085_/B sky130_fd_sc_hd__nand2_1
X_1131_ VGND VPWR VPWR VGND _1874_/D _1129_/X _1131_/S _1130_/X sky130_fd_sc_hd__mux2_1
XPHY_EDGE_ROW_25_Left_97 VPWR VGND VPWR VGND sky130_fd_sc_hd__decap_3
X_1964_ _1964_/Q clkload8/A _1964_/D VPWR VGND VPWR VGND sky130_fd_sc_hd__dfxtp_1
X_0915_ VGND VPWR VPWR VGND _1887_/Q _0923_/B _0916_/B sky130_fd_sc_hd__xor2_1
Xclkbuf_leaf_13_clk _1995_/CLK clkbuf_leaf_4_clk/A VPWR VGND VGND VPWR sky130_fd_sc_hd__clkbuf_8
X_1895_ VPWR VGND _1895_/CLK _1645_/Y _2030_/A _1895_/D VPWR VGND sky130_fd_sc_hd__edfxtp_1
X_0846_ VPWR VGND VGND VPWR _1838_/Q _0934_/A sky130_fd_sc_hd__inv_1
XFILLER_0_309 VGND VPWR VPWR VGND sky130_fd_sc_hd__decap_12
X_1329_ VPWR VGND VGND VPWR _1690_/A _1358_/D sky130_fd_sc_hd__inv_1
XFILLER_33_57 VGND VPWR VPWR VGND sky130_fd_sc_hd__decap_4
XFILLER_3_125 VGND VPWR VPWR VGND sky130_fd_sc_hd__decap_12
XFILLER_47_313 VPWR VGND VPWR VGND sky130_fd_sc_hd__decap_3
XFILLER_3_169 VGND VPWR VPWR VGND sky130_fd_sc_hd__decap_12
XFILLER_62_349 VGND VPWR VPWR VGND sky130_fd_sc_hd__decap_4
XFILLER_70_382 VGND VPWR VPWR VGND sky130_fd_sc_hd__decap_12
XFILLER_15_265 VGND VPWR VPWR VGND sky130_fd_sc_hd__decap_12
Xhold409 hold409/X _2028_/A VPWR VGND VGND VPWR sky130_fd_sc_hd__dlygate4sd3_1
X_1680_ VPWR VGND VGND VPWR _1680_/A _1680_/Y sky130_fd_sc_hd__inv_1
XFILLER_65_143 VPWR VGND VPWR VGND sky130_fd_sc_hd__decap_8
X_1114_ VGND VPWR VGND VPWR _1130_/S0 _1732_/Q _1700_/Q _1130_/S1 _1764_/Q _1796_/Q
+ _1114_/X sky130_fd_sc_hd__mux4_2
Xclkbuf_leaf_2_clk clkload1/A clkbuf_leaf_2_clk/A VPWR VGND VGND VPWR sky130_fd_sc_hd__clkbuf_8
XFILLER_24_3 VGND VPWR VPWR VGND sky130_fd_sc_hd__decap_12
XFILLER_61_393 VPWR VGND VPWR VGND sky130_fd_sc_hd__decap_6
XFILLER_53_327 VPWR VGND VPWR VGND sky130_fd_sc_hd__decap_8
X_1045_ VGND VPWR VGND VPWR _1288_/B1 _1288_/A1 _1927_/D _1044_/Y sky130_fd_sc_hd__o21ai_0
X_1947_ _1947_/Q _1994_/CLK _1947_/D VPWR VGND VPWR VGND sky130_fd_sc_hd__dfxtp_1
X_1878_ VPWR VGND _1982_/CLK _1878_/DE _1878_/Q _1878_/D VPWR VGND sky130_fd_sc_hd__edfxtp_1
XFILLER_71_113 VPWR VGND VPWR VGND sky130_fd_sc_hd__decap_8
XFILLER_29_324 VGND VPWR VPWR VGND sky130_fd_sc_hd__decap_12
XFILLER_44_89 VGND VPWR VPWR VGND sky130_fd_sc_hd__decap_4
XFILLER_5_39 VGND VPWR VPWR VGND sky130_fd_sc_hd__decap_12
XFILLER_4_401 VGND VPWR VPWR VGND sky130_fd_sc_hd__decap_12
XFILLER_47_176 VPWR VGND VPWR VGND sky130_fd_sc_hd__decap_8
XFILLER_43_393 VPWR VGND VPWR VGND sky130_fd_sc_hd__decap_8
X_1663_ VPWR VGND VGND VPWR _1691_/A _1663_/Y sky130_fd_sc_hd__inv_1
X_1801_ VPWR VGND _1993_/CLK _1801_/DE _1801_/Q _1801_/D VPWR VGND sky130_fd_sc_hd__edfxtp_1
X_1732_ VPWR VGND clkload4/A _1737_/DE _1732_/Q _1732_/D VPWR VGND sky130_fd_sc_hd__edfxtp_1
X_1594_ VGND VPWR VPWR VGND _1811_/D _1598_/B _1847_/Q sky130_fd_sc_hd__and2_0
XPHY_EDGE_ROW_7_Right_7 VPWR VGND VPWR VGND sky130_fd_sc_hd__decap_3
XFILLER_14_15 VGND VPWR VPWR VGND sky130_fd_sc_hd__decap_12
XFILLER_14_37 VPWR VGND VPWR VGND sky130_fd_sc_hd__decap_3
X_1028_ VPWR VGND VGND VPWR _1027_/X _1028_/Y _1026_/X _1287_/S sky130_fd_sc_hd__mux2i_1
XFILLER_30_47 VPWR VGND VPWR VGND sky130_fd_sc_hd__decap_6
XFILLER_5_209 VPWR VGND VPWR VGND sky130_fd_sc_hd__decap_6
XPHY_EDGE_ROW_12_Left_84 VPWR VGND VPWR VGND sky130_fd_sc_hd__decap_3
XFILLER_55_77 VGND VPWR VPWR VGND sky130_fd_sc_hd__decap_12
XFILLER_44_168 VGND VPWR VPWR VGND sky130_fd_sc_hd__decap_4
XFILLER_29_187 VPWR VGND VPWR VGND sky130_fd_sc_hd__decap_8
XFILLER_4_253 VGND VPWR VPWR VGND sky130_fd_sc_hd__decap_12
X_2000_ _2000_/Q _2000_/CLK _2000_/D VPWR VGND VPWR VGND sky130_fd_sc_hd__dfxtp_1
XFILLER_35_113 VPWR VGND VPWR VGND sky130_fd_sc_hd__decap_8
XFILLER_23_308 VPWR VGND VPWR VGND sky130_fd_sc_hd__decap_6
XFILLER_23_319 VGND VPWR VPWR VGND sky130_fd_sc_hd__decap_12
X_1646_ VPWR VGND VGND VPWR _1679_/A _1646_/Y sky130_fd_sc_hd__inv_1
X_1715_ VPWR VGND _1777_/CLK _1726_/DE _1715_/Q _1715_/D VPWR VGND sky130_fd_sc_hd__edfxtp_1
X_1577_ VPWR VGND VPWR VGND _1459_/B _0847_/Y _1686_/A _1577_/Y sky130_fd_sc_hd__a21oi_1
XFILLER_22_341 VPWR VGND VPWR VGND sky130_fd_sc_hd__decap_8
XFILLER_66_21 VPWR VGND VPWR VGND sky130_fd_sc_hd__decap_6
XFILLER_45_411 VGND VPWR VPWR VGND sky130_fd_sc_hd__decap_4
XFILLER_2_29 VGND VPWR VPWR VGND sky130_fd_sc_hd__decap_12
XFILLER_17_113 VGND VPWR VPWR VGND sky130_fd_sc_hd__decap_12
X_1500_ VPWR VGND VGND VPWR _1522_/A _1500_/B _1949_/D sky130_fd_sc_hd__nor2_1
X_1293_ VPWR VGND VGND VPWR _1293_/Y _0835_/Y _1917_/Q _1291_/Y _1292_/Y _1289_/Y
+ sky130_fd_sc_hd__o2111ai_1
X_1362_ VGND VPWR _1934_/Q _1364_/A _1889_/Q VPWR VGND sky130_fd_sc_hd__xnor2_1
X_1431_ VGND VPWR VPWR VGND _1713_/D _1433_/B _1845_/Q sky130_fd_sc_hd__and2_0
Xplace252 VPWR VGND _1350_/S _1241_/Y VPWR VGND sky130_fd_sc_hd__buf_2
XFILLER_51_414 VGND VPWR VPWR VGND sky130_fd_sc_hd__decap_12
Xplace263 VPWR VGND _1309_/A _1954_/Q VPWR VGND sky130_fd_sc_hd__buf_2
Xplace241 VPWR VGND _1529_/B _1386_/B VPWR VGND sky130_fd_sc_hd__buf_2
Xplace230 VPWR VGND _1806_/DE _1269_/X VPWR VGND sky130_fd_sc_hd__buf_2
Xplace285 VPWR VGND _1073_/S0 _1823_/Q VPWR VGND sky130_fd_sc_hd__buf_2
Xplace274 VPWR VGND _1127_/S0 _1130_/S0 VPWR VGND sky130_fd_sc_hd__buf_4
XFILLER_11_49 VPWR VGND VPWR VGND sky130_fd_sc_hd__decap_6
X_1629_ VGND VPWR VPWR VGND _1782_/D _1629_/B _1850_/Q sky130_fd_sc_hd__and2_0
XFILLER_42_414 VPWR VGND VPWR VGND sky130_fd_sc_hd__decap_6
XFILLER_10_355 VPWR VGND VPWR VGND sky130_fd_sc_hd__decap_8
XFILLER_10_377 VGND VPWR VPWR VGND sky130_fd_sc_hd__decap_12
XFILLER_45_274 VPWR VGND VPWR VGND sky130_fd_sc_hd__decap_6
X_0931_ VGND VPWR _0973_/B _1835_/Q _1834_/Q _0931_/C VPWR VGND sky130_fd_sc_hd__and3_1
X_1980_ VPWR VGND _1982_/CLK _1686_/Y _1980_/Q _1980_/D VPWR VGND sky130_fd_sc_hd__edfxtp_1
X_0862_ VPWR VGND VPWR VGND _1921_/Q _0875_/A _0885_/B _0884_/B sky130_fd_sc_hd__a21oi_1
XFILLER_13_160 VPWR VGND VPWR VGND sky130_fd_sc_hd__decap_8
X_1345_ VGND VPWR VPWR VGND _1947_/Q _1345_/X _1345_/B sky130_fd_sc_hd__xor2_1
X_1276_ VPWR VGND VGND VPWR _1283_/A _1281_/B _1276_/Y sky130_fd_sc_hd__nor2_1
X_1414_ VGND VPWR VPWR VGND _1731_/D _1418_/B _1847_/Q sky130_fd_sc_hd__and2_0
XFILLER_22_15 VGND VPWR VPWR VGND sky130_fd_sc_hd__decap_12
XFILLER_59_355 VPWR VGND VPWR VGND sky130_fd_sc_hd__decap_8
XFILLER_59_322 VGND VPWR VPWR VGND sky130_fd_sc_hd__decap_4
XFILLER_47_12 VGND VPWR VPWR VGND sky130_fd_sc_hd__decap_4
XFILLER_3_329 VPWR VGND VPWR VGND sky130_fd_sc_hd__decap_6
XFILLER_10_141 VPWR VGND VPWR VGND sky130_fd_sc_hd__decap_8
XPHY_EDGE_ROW_0_Left_72 VPWR VGND VPWR VGND sky130_fd_sc_hd__decap_3
X_1130_ VGND VPWR VGND VPWR _1130_/S0 _1743_/Q _1711_/Q _1130_/S1 _1775_/Q _1807_/Q
+ _1130_/X sky130_fd_sc_hd__mux4_2
X_1061_ VGND VPWR VGND VPWR _1057_/Y _1086_/A1 _1924_/D _1060_/Y sky130_fd_sc_hd__o21ai_0
X_0914_ VPWR VGND VGND VPWR _0923_/A _0926_/A _1886_/Q _0914_/B sky130_fd_sc_hd__maj3_1
X_1963_ _1963_/Q _1963_/CLK _1963_/D VPWR VGND VPWR VGND sky130_fd_sc_hd__dfxtp_2
X_0845_ VPWR VGND VGND VPWR _1932_/Q _0872_/A sky130_fd_sc_hd__inv_1
X_1894_ VPWR VGND _2001_/CLK _1647_/Y _2029_/A _1894_/D VPWR VGND sky130_fd_sc_hd__edfxtp_1
XFILLER_68_141 VGND VPWR VPWR VGND sky130_fd_sc_hd__decap_4
X_1328_ VPWR VGND VPWR VGND _1964_/Q _1350_/S _1328_/D _1328_/Y _1328_/B sky130_fd_sc_hd__nand4_1
X_1259_ VPWR VGND VGND VPWR _1259_/A _1829_/D _1259_/B sky130_fd_sc_hd__nand2_1
XFILLER_3_137 VGND VPWR VPWR VGND sky130_fd_sc_hd__decap_12
XFILLER_58_55 VGND VPWR VPWR VGND sky130_fd_sc_hd__decap_4
XFILLER_47_369 VPWR VGND VPWR VGND sky130_fd_sc_hd__decap_8
XFILLER_15_277 VPWR VGND VPWR VGND sky130_fd_sc_hd__decap_3
XFILLER_70_394 VGND VPWR VPWR VGND sky130_fd_sc_hd__decap_12
XFILLER_30_236 VGND VPWR VPWR VGND sky130_fd_sc_hd__decap_12
XFILLER_65_155 VGND VPWR VPWR VGND sky130_fd_sc_hd__decap_12
XFILLER_38_347 VGND VPWR VPWR VGND sky130_fd_sc_hd__decap_12
X_1113_ VGND VPWR VPWR VGND _1880_/D _1111_/X _1131_/S _1112_/X sky130_fd_sc_hd__mux2_1
X_1044_ VPWR VGND VGND VPWR _1043_/X _1044_/Y _1042_/X _1287_/S sky130_fd_sc_hd__mux2i_1
XFILLER_21_225 VGND VPWR VPWR VGND sky130_fd_sc_hd__decap_12
X_1946_ _1946_/Q _1994_/CLK _1946_/D VPWR VGND VPWR VGND sky130_fd_sc_hd__dfxtp_1
X_1877_ VPWR VGND _1982_/CLK _1922_/DE _1877_/Q _1877_/D VPWR VGND sky130_fd_sc_hd__edfxtp_1
XFILLER_9_93 VGND VPWR VPWR VGND sky130_fd_sc_hd__decap_12
XFILLER_71_147 VGND VPWR VPWR VGND sky130_fd_sc_hd__decap_12
XFILLER_56_177 VGND VPWR VPWR VGND sky130_fd_sc_hd__decap_12
XFILLER_44_339 VPWR VGND VPWR VGND sky130_fd_sc_hd__decap_8
XFILLER_4_413 VPWR VGND VPWR VGND sky130_fd_sc_hd__decap_6
X_1800_ VPWR VGND clkload5/A _1801_/DE _1800_/Q _1800_/D VPWR VGND sky130_fd_sc_hd__edfxtp_1
X_1662_ VPWR VGND VGND VPWR _1694_/A _1662_/Y sky130_fd_sc_hd__inv_1
X_1731_ VPWR VGND _2006_/CLK _1737_/DE _1731_/Q _1731_/D VPWR VGND sky130_fd_sc_hd__edfxtp_1
X_1593_ VGND VPWR VPWR VGND _1812_/D _1593_/B _1848_/Q sky130_fd_sc_hd__and2_0
XFILLER_53_169 VPWR VGND VPWR VGND sky130_fd_sc_hd__decap_8
XFILLER_34_361 VPWR VGND VPWR VGND sky130_fd_sc_hd__decap_3
X_1027_ VGND VPWR VGND VPWR _1286_/S0 _1787_/Q _1771_/Q _1286_/S1 _1803_/Q _1819_/Q
+ _1027_/X sky130_fd_sc_hd__mux4_2
Xclkbuf_3_5__f_clk VGND VPWR VGND VPWR clkbuf_0_clk/X clkbuf_3_5__f_clk/X sky130_fd_sc_hd__clkbuf_16
XFILLER_61_180 VGND VPWR VPWR VGND sky130_fd_sc_hd__decap_4
X_1929_ VPWR VGND clkload4/A _2016_/DE _1929_/Q _1929_/D VPWR VGND sky130_fd_sc_hd__edfxtp_1
XFILLER_1_405 VGND VPWR VPWR VGND sky130_fd_sc_hd__decap_12
XFILLER_39_35 VGND VPWR VPWR VGND sky130_fd_sc_hd__decap_12
XFILLER_17_317 VGND VPWR VPWR VGND sky130_fd_sc_hd__decap_12
XFILLER_55_89 VGND VPWR VPWR VGND sky130_fd_sc_hd__decap_4
XFILLER_55_67 VPWR VGND VPWR VGND sky130_fd_sc_hd__decap_6
XFILLER_4_221 VGND VPWR VPWR VGND sky130_fd_sc_hd__decap_4
XFILLER_4_265 VGND VPWR VPWR VGND sky130_fd_sc_hd__decap_12
XFILLER_16_361 VPWR VGND VPWR VGND sky130_fd_sc_hd__decap_3
X_1576_ VGND VPWR _1576_/B _1576_/Y _2020_/A VPWR VGND sky130_fd_sc_hd__xnor2_1
X_1645_ VPWR VGND VGND VPWR _1645_/A _1645_/Y sky130_fd_sc_hd__inv_1
X_1714_ VPWR VGND _1749_/CLK _1724_/DE _1714_/Q _1714_/D VPWR VGND sky130_fd_sc_hd__edfxtp_1
XFILLER_54_401 VGND VPWR VPWR VGND sky130_fd_sc_hd__decap_12
XFILLER_14_309 VGND VPWR VPWR VGND sky130_fd_sc_hd__decap_12
XFILLER_60_404 VGND VPWR VPWR VGND sky130_fd_sc_hd__decap_12
XFILLER_17_125 VGND VPWR VPWR VGND sky130_fd_sc_hd__decap_4
XFILLER_17_169 VGND VPWR VPWR VGND sky130_fd_sc_hd__decap_12
XFILLER_40_183 VGND VPWR VPWR VGND sky130_fd_sc_hd__decap_12
X_1430_ VGND VPWR VPWR VGND _1714_/D _1433_/B _1846_/Q sky130_fd_sc_hd__and2_0
X_1292_ VPWR VGND VPWR VGND _1917_/Q _0835_/Y _1313_/A _1292_/Y sky130_fd_sc_hd__a21oi_1
X_1361_ VPWR VGND VGND VPWR _1365_/A _1361_/C _1888_/Q _1361_/B sky130_fd_sc_hd__maj3_1
Xplace264 VPWR VGND _1209_/B _1951_/Q VPWR VGND sky130_fd_sc_hd__buf_2
Xplace253 VPWR VGND _1366_/B1 _0853_/Y VPWR VGND sky130_fd_sc_hd__buf_2
Xplace242 VPWR VGND _1386_/B _1283_/Y VPWR VGND sky130_fd_sc_hd__buf_2
Xplace275 VPWR VGND _1130_/S0 _1827_/Q VPWR VGND sky130_fd_sc_hd__buf_4
Xplace220 VPWR VGND _1790_/DE _1786_/DE VPWR VGND sky130_fd_sc_hd__buf_2
Xplace231 VPWR VGND _1801_/DE _1269_/X VPWR VGND sky130_fd_sc_hd__buf_4
X_1559_ VPWR VGND VPWR VGND _1558_/Y _1557_/Y _1671_/A _1973_/D sky130_fd_sc_hd__a21oi_1
X_1628_ VGND VPWR VPWR VGND _1783_/D _1630_/B _1851_/Q sky130_fd_sc_hd__and2_0
XFILLER_36_25 VPWR VGND VPWR VGND sky130_fd_sc_hd__decap_3
XFILLER_54_286 VPWR VGND VPWR VGND sky130_fd_sc_hd__decap_3
XFILLER_52_46 VGND VPWR VPWR VGND sky130_fd_sc_hd__decap_12
XFILLER_22_183 VGND VPWR VPWR VGND sky130_fd_sc_hd__decap_12
XFILLER_10_389 VGND VPWR VPWR VGND sky130_fd_sc_hd__decap_12
Xhold390 _1560_/A _2024_/A VPWR VGND VGND VPWR sky130_fd_sc_hd__dlygate4sd3_1
XFILLER_45_242 VPWR VGND VPWR VGND sky130_fd_sc_hd__decap_8
XFILLER_33_404 VGND VPWR VPWR VGND sky130_fd_sc_hd__decap_12
X_0930_ VGND VPWR _0931_/C _1832_/Q _1831_/Q _1833_/Q VPWR VGND sky130_fd_sc_hd__and3_1
X_0861_ VGND VPWR VGND VPWR _1995_/Q _1920_/Q _1919_/Q _0885_/B sky130_fd_sc_hd__o21ba_1
XFILLER_42_90 VPWR VGND VPWR VGND sky130_fd_sc_hd__decap_8
XFILLER_9_165 VPWR VGND VPWR VGND sky130_fd_sc_hd__decap_3
X_1413_ VGND VPWR VPWR VGND _1732_/D _1418_/B _1848_/Q sky130_fd_sc_hd__and2_0
XFILLER_5_393 VGND VPWR VPWR VGND sky130_fd_sc_hd__decap_12
X_1344_ VGND VPWR VPWR VGND _1165_/B _1135_/Y _1945_/Q _1345_/B _1343_/Y sky130_fd_sc_hd__a31oi_1
XFILLER_36_253 VGND VPWR VPWR VGND sky130_fd_sc_hd__decap_4
XFILLER_36_231 VPWR VGND VPWR VGND sky130_fd_sc_hd__decap_3
X_1275_ VPWR VGND VGND VPWR _1892_/Q _1281_/B _1891_/Q sky130_fd_sc_hd__nand2_1
XFILLER_3_51 VGND VPWR VPWR VGND sky130_fd_sc_hd__decap_4
XFILLER_36_297 VPWR VGND VPWR VGND sky130_fd_sc_hd__decap_8
Xfanout100 VPWR VGND _1688_/A _1682_/A VPWR VGND sky130_fd_sc_hd__buf_2
XFILLER_59_389 VPWR VGND VPWR VGND sky130_fd_sc_hd__decap_3
XFILLER_59_378 VPWR VGND VPWR VGND sky130_fd_sc_hd__decap_3
XFILLER_59_367 VPWR VGND VPWR VGND sky130_fd_sc_hd__decap_3
XPHY_EDGE_ROW_29_Right_29 VPWR VGND VPWR VGND sky130_fd_sc_hd__decap_3
XPHY_EDGE_ROW_38_Right_38 VPWR VGND VPWR VGND sky130_fd_sc_hd__decap_3
XFILLER_8_29 VGND VPWR VPWR VGND sky130_fd_sc_hd__decap_12
XFILLER_10_131 VGND VPWR VPWR VGND sky130_fd_sc_hd__decap_4
XFILLER_10_186 VGND VPWR VPWR VGND sky130_fd_sc_hd__decap_4
XFILLER_69_109 VPWR VGND VPWR VGND sky130_fd_sc_hd__decap_3
XFILLER_10_197 VGND VPWR VPWR VGND sky130_fd_sc_hd__decap_12
XPHY_EDGE_ROW_47_Right_47 VPWR VGND VPWR VGND sky130_fd_sc_hd__decap_3
X_1060_ VPWR VGND VGND VPWR _1059_/X _1060_/Y _1058_/X _1084_/S sky130_fd_sc_hd__mux2i_1
XPHY_EDGE_ROW_56_Right_56 VPWR VGND VPWR VGND sky130_fd_sc_hd__decap_3
X_1962_ _1962_/Q clkload7/A _1962_/D VPWR VGND VPWR VGND sky130_fd_sc_hd__dfxtp_1
XFILLER_18_264 VPWR VGND VPWR VGND sky130_fd_sc_hd__decap_8
XFILLER_18_297 VPWR VGND VPWR VGND sky130_fd_sc_hd__decap_8
X_1893_ VPWR VGND clkload8/A _1655_/Y _1893_/Q _1893_/D VPWR VGND sky130_fd_sc_hd__edfxtp_1
X_0844_ VPWR VGND VGND VPWR _1931_/Q _0844_/Y sky130_fd_sc_hd__inv_1
X_0913_ VGND VPWR VPWR VGND _1886_/Q _0926_/B _0914_/B sky130_fd_sc_hd__xor2_1
XPHY_EDGE_ROW_65_Right_65 VPWR VGND VPWR VGND sky130_fd_sc_hd__decap_3
XFILLER_68_197 VPWR VGND VPWR VGND sky130_fd_sc_hd__decap_8
X_1189_ VGND VPWR VGND VPWR _1222_/C _1162_/Y _1189_/Y _1188_/X sky130_fd_sc_hd__o21ai_0
X_1258_ VPWR VGND VGND VPWR _1305_/B _1538_/B _1259_/B sky130_fd_sc_hd__nor2_1
X_1327_ VPWR VGND VGND VPWR _1350_/S _1327_/Y _1328_/D sky130_fd_sc_hd__nand2_1
XFILLER_56_359 VGND VPWR VPWR VGND sky130_fd_sc_hd__decap_4
XFILLER_33_15 VGND VPWR VPWR VGND sky130_fd_sc_hd__decap_12
XFILLER_3_149 VGND VPWR VPWR VGND sky130_fd_sc_hd__decap_12
XFILLER_3_105 VPWR VGND VPWR VGND sky130_fd_sc_hd__decap_6
XFILLER_58_89 VPWR VGND VPWR VGND sky130_fd_sc_hd__decap_8
XFILLER_47_337 VPWR VGND VPWR VGND sky130_fd_sc_hd__decap_8
XFILLER_70_340 VPWR VGND VPWR VGND sky130_fd_sc_hd__decap_3
XFILLER_30_259 VGND VPWR VPWR VGND sky130_fd_sc_hd__decap_4
XFILLER_30_248 VGND VPWR VPWR VGND sky130_fd_sc_hd__decap_4
XFILLER_38_359 VGND VPWR VPWR VGND sky130_fd_sc_hd__decap_4
X_1112_ VGND VPWR VGND VPWR _1127_/S0 _1749_/Q _1717_/Q _1127_/S1 _1781_/Q _1813_/Q
+ _1112_/X sky130_fd_sc_hd__mux4_2
X_1043_ VGND VPWR VGND VPWR _1286_/S0 _1783_/Q _1767_/Q _1286_/S1 _1799_/Q _1815_/Q
+ _1043_/X sky130_fd_sc_hd__mux4_2
XFILLER_0_41 VGND VPWR VPWR VGND sky130_fd_sc_hd__decap_12
XFILLER_0_85 VGND VPWR VPWR VGND sky130_fd_sc_hd__decap_12
X_1945_ _1945_/Q _1994_/CLK _1945_/D VPWR VGND VPWR VGND sky130_fd_sc_hd__dfxtp_1
XFILLER_21_237 VGND VPWR VPWR VGND sky130_fd_sc_hd__decap_4
XFILLER_21_259 VPWR VGND VPWR VGND sky130_fd_sc_hd__decap_3
X_1876_ VPWR VGND _1954_/CLK _1922_/DE _1876_/Q _1876_/D VPWR VGND sky130_fd_sc_hd__edfxtp_1
XFILLER_56_112 VGND VPWR VPWR VGND sky130_fd_sc_hd__decap_12
XFILLER_29_337 VPWR VGND VPWR VGND sky130_fd_sc_hd__decap_8
XFILLER_28_15 VGND VPWR VPWR VGND sky130_fd_sc_hd__decap_12
XFILLER_60_79 VGND VPWR VPWR VGND sky130_fd_sc_hd__decap_4
XFILLER_47_101 VPWR VGND VPWR VGND sky130_fd_sc_hd__decap_3
XFILLER_18_81 VPWR VGND VPWR VGND sky130_fd_sc_hd__decap_3
XFILLER_70_170 VPWR VGND VPWR VGND sky130_fd_sc_hd__decap_8
X_1661_ VPWR VGND VGND VPWR _1691_/A _1661_/Y sky130_fd_sc_hd__inv_1
X_1592_ VGND VPWR VPWR VGND _1813_/D _1598_/B _1849_/Q sky130_fd_sc_hd__and2_0
XFILLER_11_281 VPWR VGND VPWR VGND sky130_fd_sc_hd__decap_8
X_1730_ VPWR VGND _1777_/CLK _1737_/DE _1730_/Q _1730_/D VPWR VGND sky130_fd_sc_hd__edfxtp_1
XFILLER_66_421 VGND VPWR VPWR VGND sky130_fd_sc_hd__decap_4
XPHY_EDGE_ROW_37_Left_109 VPWR VGND VPWR VGND sky130_fd_sc_hd__decap_3
XPHY_EDGE_ROW_46_Left_118 VPWR VGND VPWR VGND sky130_fd_sc_hd__decap_3
X_1026_ VGND VPWR VGND VPWR _1286_/S0 _1723_/Q _1707_/Q _1286_/S1 _1739_/Q _1755_/Q
+ _1026_/X sky130_fd_sc_hd__mux4_2
XFILLER_19_381 VPWR VGND VPWR VGND sky130_fd_sc_hd__decap_8
X_1859_ VPWR VGND _1984_/CLK _1878_/DE _1859_/Q _1859_/D VPWR VGND sky130_fd_sc_hd__edfxtp_1
X_1928_ VPWR VGND _1995_/CLK _1932_/DE _1928_/Q _1928_/D VPWR VGND sky130_fd_sc_hd__edfxtp_1
XPHY_EDGE_ROW_55_Left_127 VPWR VGND VPWR VGND sky130_fd_sc_hd__decap_3
XFILLER_39_47 VPWR VGND VPWR VGND sky130_fd_sc_hd__decap_8
XFILLER_1_417 VPWR VGND VPWR VGND sky130_fd_sc_hd__decap_8
XFILLER_55_57 VGND VPWR VPWR VGND sky130_fd_sc_hd__decap_4
XFILLER_17_329 VPWR VGND VPWR VGND sky130_fd_sc_hd__decap_6
XPHY_EDGE_ROW_64_Left_136 VPWR VGND VPWR VGND sky130_fd_sc_hd__decap_3
XFILLER_40_376 VPWR VGND VPWR VGND sky130_fd_sc_hd__decap_8
XFILLER_25_384 VPWR VGND VPWR VGND sky130_fd_sc_hd__decap_8
XFILLER_48_421 VGND VPWR VPWR VGND sky130_fd_sc_hd__decap_4
XFILLER_4_277 VGND VPWR VPWR VGND sky130_fd_sc_hd__decap_12
XFILLER_35_137 VPWR VGND VPWR VGND sky130_fd_sc_hd__decap_6
XFILLER_31_343 VGND VPWR VPWR VGND sky130_fd_sc_hd__decap_12
X_1713_ VPWR VGND _1777_/CLK _1726_/DE _1713_/Q _1713_/D VPWR VGND sky130_fd_sc_hd__edfxtp_1
X_1575_ VPWR VGND VPWR VGND _1574_/Y _1573_/Y _1686_/A _1969_/D sky130_fd_sc_hd__a21oi_1
X_1644_ VPWR VGND VGND VPWR _1645_/A _1644_/Y sky130_fd_sc_hd__inv_1
XFILLER_66_295 VPWR VGND VPWR VGND sky130_fd_sc_hd__decap_8
XFILLER_54_413 VPWR VGND VPWR VGND sky130_fd_sc_hd__decap_6
X_1009_ VPWR VGND VGND VPWR _1209_/B _1009_/B _1355_/A sky130_fd_sc_hd__nor2_1
XFILLER_22_365 VPWR VGND VPWR VGND sky130_fd_sc_hd__decap_8
XFILLER_25_16 VGND VPWR VPWR VGND sky130_fd_sc_hd__decap_12
XFILLER_22_398 VGND VPWR VPWR VGND sky130_fd_sc_hd__decap_12
XFILLER_1_225 VGND VPWR VPWR VGND sky130_fd_sc_hd__decap_12
XFILLER_60_416 VGND VPWR VPWR VGND sky130_fd_sc_hd__decap_4
X_1360_ VPWR VGND VGND VPWR _1360_/A _1360_/B _1912_/D _1360_/C sky130_fd_sc_hd__nand3_1
X_1291_ VGND VPWR _1915_/Q _1291_/Y _1957_/Q VPWR VGND sky130_fd_sc_hd__xnor2_1
XFILLER_63_276 VGND VPWR VPWR VGND sky130_fd_sc_hd__decap_4
Xplace210 VPWR VGND _1353_/D _1690_/A VPWR VGND sky130_fd_sc_hd__buf_2
Xplace265 VPWR VGND _1157_/B _1950_/Q VPWR VGND sky130_fd_sc_hd__buf_2
Xplace254 VPWR VGND _0998_/A1 _0945_/A1 VPWR VGND sky130_fd_sc_hd__buf_2
Xplace221 VPWR VGND _1786_/DE _1280_/Y VPWR VGND sky130_fd_sc_hd__buf_2
Xplace276 VPWR VGND _1131_/S _1826_/Q VPWR VGND sky130_fd_sc_hd__buf_2
Xplace243 VPWR VGND _1708_/DE _1710_/DE VPWR VGND sky130_fd_sc_hd__buf_2
Xplace232 VPWR VGND _1598_/B _1593_/B VPWR VGND sky130_fd_sc_hd__buf_2
XFILLER_23_107 VGND VPWR VPWR VGND sky130_fd_sc_hd__decap_4
X_1558_ VPWR VGND VPWR VGND _2025_/A _1560_/B _1558_/Y _1867_/Q _1608_/A sky130_fd_sc_hd__a22oi_1
X_1489_ VPWR VGND VGND VPWR _1309_/A _1693_/B _1489_/A1 _1499_/S sky130_fd_sc_hd__mux2i_1
X_1627_ VGND VPWR VPWR VGND _1784_/D _1629_/B _1852_/Q sky130_fd_sc_hd__and2_0
Xclkbuf_leaf_34_clk clkload5/A clkbuf_3_1__f_clk/X VPWR VGND VGND VPWR sky130_fd_sc_hd__clkbuf_8
Xhold380 _2009_/D _1815_/Q VPWR VGND VGND VPWR sky130_fd_sc_hd__dlygate4sd3_1
XFILLER_7_3 VGND VPWR VPWR VGND sky130_fd_sc_hd__decap_12
Xhold391 _1972_/D _1563_/Y VPWR VGND VGND VPWR sky130_fd_sc_hd__dlygate4sd3_1
Xclkbuf_leaf_25_clk _2006_/CLK clkbuf_3_5__f_clk/X VPWR VGND VGND VPWR sky130_fd_sc_hd__clkbuf_8
XFILLER_26_81 VPWR VGND VPWR VGND sky130_fd_sc_hd__decap_3
X_0860_ VPWR VGND VGND VPWR _1930_/Q _0875_/C _0870_/B sky130_fd_sc_hd__nor2_1
XFILLER_9_144 VPWR VGND VPWR VGND sky130_fd_sc_hd__decap_3
X_1343_ VPWR VGND VGND VPWR _1140_/B _1343_/B _1343_/Y _1946_/Q sky130_fd_sc_hd__nor3b_1
X_1412_ VGND VPWR VPWR VGND _1733_/D _1418_/B _1849_/Q sky130_fd_sc_hd__and2_0
XFILLER_5_361 VGND VPWR VPWR VGND sky130_fd_sc_hd__decap_12
XFILLER_68_379 VGND VPWR VPWR VGND sky130_fd_sc_hd__decap_12
X_1274_ VGND VPWR VGND VPWR _1328_/B _1283_/A _1274_/Y _1273_/B sky130_fd_sc_hd__o21ai_0
XFILLER_24_405 VPWR VGND VPWR VGND sky130_fd_sc_hd__decap_8
Xclkbuf_leaf_16_clk _1983_/CLK clkbuf_3_6__f_clk/X VPWR VGND VGND VPWR sky130_fd_sc_hd__clkbuf_8
X_0989_ VPWR VGND VPWR VGND _0989_/X _0838_/Y _0931_/C _0988_/Y _0840_/Y _0987_/Y
+ sky130_fd_sc_hd__o32a_1
Xfanout101 VGND VPWR _1682_/A _1671_/A VPWR VGND sky130_fd_sc_hd__clkdlybuf4s15_1
XFILLER_47_25 VPWR VGND VPWR VGND sky130_fd_sc_hd__decap_8
XFILLER_63_46 VPWR VGND VPWR VGND sky130_fd_sc_hd__decap_8
X_1892_ VPWR VGND clkload7/A _1654_/Y _1892_/Q _1892_/D VPWR VGND sky130_fd_sc_hd__edfxtp_1
X_0912_ VPWR VGND VGND VPWR _0926_/A _0928_/A _1885_/Q _0912_/B sky130_fd_sc_hd__maj3_1
X_1961_ _1961_/Q _2000_/CLK _1961_/D VPWR VGND VPWR VGND sky130_fd_sc_hd__dfxtp_2
X_0843_ VPWR VGND VGND VPWR _1926_/Q _0857_/A sky130_fd_sc_hd__inv_1
XFILLER_68_154 VGND VPWR VPWR VGND sky130_fd_sc_hd__decap_4
X_1326_ VGND VPWR _1325_/Y _1964_/Q _1328_/D _1306_/Y VPWR VGND sky130_fd_sc_hd__o21ai_1
Xclkbuf_leaf_5_clk _2000_/CLK clkbuf_leaf_9_clk/A VPWR VGND VGND VPWR sky130_fd_sc_hd__clkbuf_8
X_1188_ VGND VPWR VPWR VGND _1943_/Q _1188_/X _1307_/A sky130_fd_sc_hd__xor2_1
X_1257_ VGND VPWR _1538_/B _1353_/B _1963_/Q _1304_/C VPWR VGND sky130_fd_sc_hd__and3_1
XFILLER_59_154 VPWR VGND VPWR VGND sky130_fd_sc_hd__decap_8
XFILLER_65_113 VGND VPWR VPWR VGND sky130_fd_sc_hd__decap_12
XFILLER_65_102 VPWR VGND VPWR VGND sky130_fd_sc_hd__decap_8
X_1111_ VGND VPWR VGND VPWR _1127_/S0 _1733_/Q _1701_/Q _1127_/S1 _1765_/Q _1797_/Q
+ _1111_/X sky130_fd_sc_hd__mux4_2
X_1042_ VGND VPWR VGND VPWR _1286_/S0 _1719_/Q _1703_/Q _1286_/S1 _1735_/Q _1751_/Q
+ _1042_/X sky130_fd_sc_hd__mux4_2
XFILLER_0_53 VPWR VGND VPWR VGND sky130_fd_sc_hd__decap_3
XFILLER_0_97 VGND VPWR VPWR VGND sky130_fd_sc_hd__decap_12
X_1944_ _1944_/Q _1988_/CLK _1944_/D VPWR VGND VPWR VGND sky130_fd_sc_hd__dfxtp_1
X_1875_ VPWR VGND _1954_/CLK _1922_/DE _1875_/Q _1875_/D VPWR VGND sky130_fd_sc_hd__edfxtp_1
XFILLER_9_51 VGND VPWR VPWR VGND sky130_fd_sc_hd__decap_4
XFILLER_21_216 VPWR VGND VPWR VGND sky130_fd_sc_hd__decap_8
XFILLER_0_109 VPWR VGND VPWR VGND sky130_fd_sc_hd__decap_3
X_1309_ VPWR VGND VGND VPWR _1309_/A _1321_/B _1311_/B sky130_fd_sc_hd__nand2_1
XFILLER_29_316 VPWR VGND VPWR VGND sky130_fd_sc_hd__decap_3
XFILLER_52_385 VGND VPWR VPWR VGND sky130_fd_sc_hd__decap_4
XFILLER_60_58 VGND VPWR VPWR VGND sky130_fd_sc_hd__decap_4
XFILLER_69_89 VGND VPWR VPWR VGND sky130_fd_sc_hd__decap_12
XFILLER_43_385 VPWR VGND VPWR VGND sky130_fd_sc_hd__decap_6
XFILLER_34_81 VPWR VGND VPWR VGND sky130_fd_sc_hd__decap_3
XFILLER_11_271 VPWR VGND VPWR VGND sky130_fd_sc_hd__decap_8
X_1660_ VPWR VGND VGND VPWR _1689_/A _1660_/Y sky130_fd_sc_hd__inv_1
XFILLER_7_264 VGND VPWR VPWR VGND sky130_fd_sc_hd__decap_12
X_1591_ VGND VPWR VPWR VGND _1814_/D _1598_/B _1850_/Q sky130_fd_sc_hd__and2_0
XFILLER_22_3 VGND VPWR VPWR VGND sky130_fd_sc_hd__decap_12
XFILLER_46_190 VPWR VGND VPWR VGND sky130_fd_sc_hd__decap_6
X_1025_ VGND VPWR VGND VPWR _1288_/B1 _1288_/A1 _1932_/D _1024_/Y sky130_fd_sc_hd__o21ai_0
XFILLER_14_29 VPWR VGND VPWR VGND sky130_fd_sc_hd__decap_8
X_1927_ VPWR VGND _1995_/CLK _1932_/DE _1927_/Q _1927_/D VPWR VGND sky130_fd_sc_hd__edfxtp_1
X_1858_ VPWR VGND _1963_/CLK _1650_/Y _1858_/Q _1858_/D VPWR VGND sky130_fd_sc_hd__edfxtp_1
X_1789_ VPWR VGND clkload1/A _1790_/DE _1789_/Q _1789_/D VPWR VGND sky130_fd_sc_hd__edfxtp_1
XFILLER_44_127 VPWR VGND VPWR VGND sky130_fd_sc_hd__decap_3
XFILLER_44_116 VPWR VGND VPWR VGND sky130_fd_sc_hd__decap_8
XFILLER_71_57 VGND VPWR VPWR VGND sky130_fd_sc_hd__decap_12
XFILLER_4_289 VGND VPWR VPWR VGND sky130_fd_sc_hd__decap_12
XFILLER_16_396 VGND VPWR VPWR VGND sky130_fd_sc_hd__decap_12
XFILLER_31_399 VGND VPWR VPWR VGND sky130_fd_sc_hd__decap_12
XFILLER_6_41 VGND VPWR VPWR VGND sky130_fd_sc_hd__decap_12
X_1712_ VPWR VGND _1895_/CLK _1724_/DE _1712_/Q _1712_/D VPWR VGND sky130_fd_sc_hd__edfxtp_1
X_1643_ VPWR VGND VGND VPWR _1645_/A _1643_/Y sky130_fd_sc_hd__inv_1
X_1574_ VPWR VGND VPWR VGND _2021_/A _1460_/B _1574_/Y hold414/X _1459_/B sky130_fd_sc_hd__a22oi_1
XFILLER_6_85 VGND VPWR VPWR VGND sky130_fd_sc_hd__decap_12
XFILLER_66_263 VPWR VGND VPWR VGND sky130_fd_sc_hd__decap_3
XFILLER_66_230 VPWR VGND VPWR VGND sky130_fd_sc_hd__decap_6
XPHY_EDGE_ROW_16_Left_88 VPWR VGND VPWR VGND sky130_fd_sc_hd__decap_3
X_1008_ VPWR VGND VGND VPWR _1157_/B _1009_/B _1133_/B sky130_fd_sc_hd__nand2_1
XFILLER_25_39 VGND VPWR VPWR VGND sky130_fd_sc_hd__decap_12
XFILLER_49_208 VPWR VGND VPWR VGND sky130_fd_sc_hd__decap_3
XFILLER_1_237 VGND VPWR VPWR VGND sky130_fd_sc_hd__decap_12
XFILLER_40_174 VPWR VGND VPWR VGND sky130_fd_sc_hd__decap_6
XFILLER_40_163 VGND VPWR VPWR VGND sky130_fd_sc_hd__decap_4
XFILLER_40_141 VPWR VGND VPWR VGND sky130_fd_sc_hd__decap_6
XFILLER_9_337 VGND VPWR VPWR VGND sky130_fd_sc_hd__decap_12
Xplace200 VPWR VGND _1917_/DE _1358_/D VPWR VGND sky130_fd_sc_hd__buf_2
Xplace211 VPWR VGND _1690_/A _1328_/Y VPWR VGND sky130_fd_sc_hd__buf_2
X_1290_ VPWR VGND VGND VPWR _1935_/Q _1313_/A _1912_/Q sky130_fd_sc_hd__nand2_1
XFILLER_0_281 VPWR VGND VPWR VGND sky130_fd_sc_hd__decap_8
Xplace255 VPWR VGND _0945_/A1 _0853_/Y VPWR VGND sky130_fd_sc_hd__buf_2
Xplace266 VPWR VGND _1219_/A _1949_/Q VPWR VGND sky130_fd_sc_hd__buf_2
Xplace277 VPWR VGND _1084_/S _1287_/S VPWR VGND sky130_fd_sc_hd__buf_4
Xplace233 VPWR VGND _1593_/B _1265_/Y VPWR VGND sky130_fd_sc_hd__buf_2
Xplace244 VPWR VGND _1710_/DE _1277_/Y VPWR VGND sky130_fd_sc_hd__buf_2
Xplace222 VPWR VGND _1629_/B _1630_/B VPWR VGND sky130_fd_sc_hd__buf_2
X_1626_ VGND VPWR VPWR VGND _1785_/D _1629_/B _1853_/Q sky130_fd_sc_hd__and2_0
X_1557_ VPWR VGND VGND VPWR _1606_/C _1557_/Y _1557_/B sky130_fd_sc_hd__nand2_1
X_1488_ VPWR VGND VGND VPWR _1686_/A _1692_/B _1955_/D sky130_fd_sc_hd__nor2_1
XFILLER_52_15 VGND VPWR VPWR VGND sky130_fd_sc_hd__decap_12
XFILLER_39_263 VGND VPWR VPWR VGND sky130_fd_sc_hd__decap_12
XFILLER_22_141 VGND VPWR VPWR VGND sky130_fd_sc_hd__decap_12
Xhold381 _2007_/D _1813_/Q VPWR VGND VGND VPWR sky130_fd_sc_hd__dlygate4sd3_1
Xhold392 _2015_/D _1821_/Q VPWR VGND VGND VPWR sky130_fd_sc_hd__dlygate4sd3_1
Xhold370 _2014_/D _1820_/Q VPWR VGND VGND VPWR sky130_fd_sc_hd__dlygate4sd3_1
XFILLER_45_233 VGND VPWR VPWR VGND sky130_fd_sc_hd__decap_4
XFILLER_42_70 VGND VPWR VPWR VGND sky130_fd_sc_hd__decap_12
XFILLER_5_373 VGND VPWR VPWR VGND sky130_fd_sc_hd__decap_12
XFILLER_68_303 VGND VPWR VPWR VGND sky130_fd_sc_hd__decap_4
X_1342_ VPWR VGND VGND VPWR _1960_/Q _1342_/B _1911_/D sky130_fd_sc_hd__nor2_1
X_1273_ VPWR VGND VGND VPWR _1273_/B _1527_/B _1283_/A sky130_fd_sc_hd__nor2_2
X_1411_ VGND VPWR VPWR VGND _1734_/D _1418_/B _1850_/Q sky130_fd_sc_hd__and2_0
XFILLER_51_225 VGND VPWR VPWR VGND sky130_fd_sc_hd__decap_12
X_0988_ VPWR VGND VPWR VGND _1832_/Q _1831_/Q _1833_/Q _0988_/Y sky130_fd_sc_hd__a21oi_1
X_1609_ VPWR VGND VGND VPWR _1608_/A _1609_/A _1610_/C sky130_fd_sc_hd__nor2b_1
Xfanout102 VGND VPWR _1671_/A _1686_/A VPWR VGND sky130_fd_sc_hd__clkdlybuf4s15_1
XPHY_EDGE_ROW_19_Left_91 VPWR VGND VPWR VGND sky130_fd_sc_hd__decap_3
XFILLER_2_365 VGND VPWR VPWR VGND sky130_fd_sc_hd__decap_12
XFILLER_2_321 VGND VPWR VPWR VGND sky130_fd_sc_hd__decap_12
XFILLER_33_225 VPWR VGND VPWR VGND sky130_fd_sc_hd__decap_6
X_1960_ _1960_/Q clkload7/A _1960_/D VPWR VGND VPWR VGND sky130_fd_sc_hd__dfxtp_2
X_0842_ VPWR VGND VGND VPWR _1923_/Q _0883_/A sky130_fd_sc_hd__inv_1
X_1891_ VPWR VGND _1963_/CLK _1648_/Y _1891_/Q _1891_/D VPWR VGND sky130_fd_sc_hd__edfxtp_1
X_0911_ VGND VPWR VPWR VGND _1885_/Q _0928_/B _0912_/B sky130_fd_sc_hd__xor2_1
XFILLER_52_3 VGND VPWR VPWR VGND sky130_fd_sc_hd__decap_12
XFILLER_68_188 VPWR VGND VPWR VGND sky130_fd_sc_hd__decap_8
X_1325_ VPWR VGND VPWR VGND _1311_/B _1012_/Y _1324_/Y _1325_/Y sky130_fd_sc_hd__a21oi_1
X_1256_ VPWR VGND VGND VPWR _1353_/B _1360_/B _1304_/C sky130_fd_sc_hd__nand2_1
XFILLER_64_361 VPWR VGND VPWR VGND sky130_fd_sc_hd__decap_3
X_1187_ VPWR VGND VGND VPWR _1881_/D _1187_/Y _1221_/B sky130_fd_sc_hd__nand2_1
XFILLER_24_258 VGND VPWR VPWR VGND sky130_fd_sc_hd__decap_4
XFILLER_59_144 VPWR VGND VPWR VGND sky130_fd_sc_hd__decap_6
XFILLER_62_309 VGND VPWR VPWR VGND sky130_fd_sc_hd__decap_4
XFILLER_59_199 VGND VPWR VPWR VGND sky130_fd_sc_hd__decap_12
XFILLER_55_383 VPWR VGND VPWR VGND sky130_fd_sc_hd__decap_6
XFILLER_15_225 VGND VPWR VPWR VGND sky130_fd_sc_hd__decap_12
XPHY_EDGE_ROW_4_Left_76 VPWR VGND VPWR VGND sky130_fd_sc_hd__decap_3
XFILLER_65_125 VGND VPWR VPWR VGND sky130_fd_sc_hd__decap_4
X_1110_ VGND VPWR VPWR VGND _1881_/D _1108_/X _1131_/S _1109_/X sky130_fd_sc_hd__mux2_1
X_1041_ VGND VPWR VGND VPWR _1288_/B1 _1288_/A1 _1928_/D _1040_/Y sky130_fd_sc_hd__o21ai_0
X_1943_ _1943_/Q _1986_/CLK _1943_/D VPWR VGND VPWR VGND sky130_fd_sc_hd__dfxtp_1
X_1874_ VPWR VGND _1954_/CLK _2008_/DE _1874_/Q _1874_/D VPWR VGND sky130_fd_sc_hd__edfxtp_1
X_1239_ VGND VPWR VPWR VGND _1843_/D _1501_/A1 _1349_/S _1978_/Q sky130_fd_sc_hd__mux2_1
X_1308_ VGND VPWR _1319_/B _1313_/B _1916_/Q VPWR VGND sky130_fd_sc_hd__xnor2_1
XFILLER_69_57 VGND VPWR VPWR VGND sky130_fd_sc_hd__decap_12
XFILLER_60_48 VPWR VGND VPWR VGND sky130_fd_sc_hd__decap_6
XFILLER_20_261 VPWR VGND VPWR VGND sky130_fd_sc_hd__decap_3
XFILLER_20_272 VGND VPWR VPWR VGND sky130_fd_sc_hd__decap_12
XFILLER_28_361 VPWR VGND VPWR VGND sky130_fd_sc_hd__decap_3
X_1590_ VGND VPWR VPWR VGND _1815_/D _1593_/B _1851_/Q sky130_fd_sc_hd__and2_0
XFILLER_7_276 VGND VPWR VPWR VGND sky130_fd_sc_hd__decap_4
XFILLER_26_309 VPWR VGND VPWR VGND sky130_fd_sc_hd__decap_6
XFILLER_15_3 VGND VPWR VPWR VGND sky130_fd_sc_hd__decap_12
X_1024_ VPWR VGND VGND VPWR _1023_/X _1024_/Y _1022_/X _1287_/S sky130_fd_sc_hd__mux2i_1
XFILLER_19_361 VGND VPWR VPWR VGND sky130_fd_sc_hd__decap_12
XFILLER_34_353 VPWR VGND VPWR VGND sky130_fd_sc_hd__decap_8
X_1926_ VPWR VGND _1995_/CLK _1926_/DE _1926_/Q _1926_/D VPWR VGND sky130_fd_sc_hd__edfxtp_1
X_1857_ VPWR VGND _1963_/CLK _1657_/Y _1857_/Q _1857_/D VPWR VGND sky130_fd_sc_hd__edfxtp_1
X_1788_ VPWR VGND _1788_/CLK _1790_/DE _1788_/Q _1788_/D VPWR VGND sky130_fd_sc_hd__edfxtp_1
XFILLER_57_401 VPWR VGND VPWR VGND sky130_fd_sc_hd__decap_8
XFILLER_71_69 VGND VPWR VPWR VGND sky130_fd_sc_hd__decap_4
XFILLER_52_183 VPWR VGND VPWR VGND sky130_fd_sc_hd__decap_6
XFILLER_48_412 VPWR VGND VPWR VGND sky130_fd_sc_hd__decap_8
XFILLER_45_81 VGND VPWR VPWR VGND sky130_fd_sc_hd__decap_4
X_1642_ VPWR VGND VGND VPWR _1645_/A _1642_/Y sky130_fd_sc_hd__inv_1
XFILLER_6_53 VGND VPWR VPWR VGND sky130_fd_sc_hd__decap_12
X_1711_ VPWR VGND _1807_/CLK _1724_/DE _1711_/Q _1711_/D VPWR VGND sky130_fd_sc_hd__edfxtp_1
X_1573_ VPWR VGND VGND VPWR _1573_/A _1573_/B _1573_/Y _1573_/C sky130_fd_sc_hd__nand3_1
XFILLER_39_423 VPWR VGND VPWR VGND sky130_fd_sc_hd__decap_3
XFILLER_6_97 VPWR VGND VPWR VGND sky130_fd_sc_hd__decap_8
X_1007_ VPWR VGND VGND VPWR _1357_/A _1219_/A _1007_/C _1133_/B sky130_fd_sc_hd__nor3_2
X_1909_ VPWR VGND _2016_/CLK _1656_/Y _2044_/A _1909_/D VPWR VGND sky130_fd_sc_hd__edfxtp_1
XFILLER_1_205 VGND VPWR VPWR VGND sky130_fd_sc_hd__decap_12
XFILLER_1_249 VGND VPWR VPWR VGND sky130_fd_sc_hd__decap_12
XFILLER_9_305 VGND VPWR VPWR VGND sky130_fd_sc_hd__decap_12
XFILLER_13_356 VGND VPWR VPWR VGND sky130_fd_sc_hd__decap_12
XFILLER_15_40 VGND VPWR VPWR VGND sky130_fd_sc_hd__decap_12
XFILLER_25_161 VPWR VGND VPWR VGND sky130_fd_sc_hd__decap_6
XFILLER_40_197 VGND VPWR VPWR VGND sky130_fd_sc_hd__decap_12
XFILLER_9_349 VGND VPWR VPWR VGND sky130_fd_sc_hd__decap_12
Xplace201 VPWR VGND _1869_/DE _1358_/D VPWR VGND sky130_fd_sc_hd__buf_2
Xplace234 VPWR VGND _1218_/A _1172_/X VPWR VGND sky130_fd_sc_hd__buf_2
XFILLER_51_407 VPWR VGND VPWR VGND sky130_fd_sc_hd__decap_3
XFILLER_48_231 VPWR VGND VPWR VGND sky130_fd_sc_hd__decap_3
Xplace212 VPWR VGND _1086_/A1 _1288_/A1 VPWR VGND sky130_fd_sc_hd__buf_2
Xplace223 VPWR VGND _1630_/B _1279_/Y VPWR VGND sky130_fd_sc_hd__buf_2
XFILLER_36_415 VGND VPWR VPWR VGND sky130_fd_sc_hd__decap_4
Xplace245 VPWR VGND _1448_/B _1525_/B VPWR VGND sky130_fd_sc_hd__buf_2
Xplace267 VPWR VGND _1357_/A _1948_/Q VPWR VGND sky130_fd_sc_hd__buf_2
Xplace256 VPWR VGND _1367_/A1 _0852_/Y VPWR VGND sky130_fd_sc_hd__buf_2
Xplace278 VPWR VGND _1287_/S _1825_/Q VPWR VGND sky130_fd_sc_hd__buf_2
X_1556_ VPWR VGND VGND VPWR _1556_/C _1606_/D _1608_/A _1557_/B sky130_fd_sc_hd__nor3_1
X_1625_ VGND VPWR VPWR VGND _1786_/D _1630_/B _1854_/Q sky130_fd_sc_hd__and2_0
X_1487_ VPWR VGND VGND VPWR _1307_/A _1692_/B _1487_/A1 _1499_/S sky130_fd_sc_hd__mux2i_1
XFILLER_39_275 VGND VPWR VPWR VGND sky130_fd_sc_hd__decap_4
X_2039_ VPWR VGND _2039_/X _2039_/A VPWR VGND sky130_fd_sc_hd__buf_2
Xhold393 hold393/X _1914_/Q VPWR VGND VGND VPWR sky130_fd_sc_hd__dlygate4sd3_1
Xhold382 _1833_/D _1938_/Q VPWR VGND VGND VPWR sky130_fd_sc_hd__dlygate4sd3_1
Xhold360 _1905_/D _2012_/Q VPWR VGND VGND VPWR sky130_fd_sc_hd__dlygate4sd3_1
Xhold371 _2005_/D _1811_/Q VPWR VGND VGND VPWR sky130_fd_sc_hd__dlygate4sd3_1
XFILLER_9_113 VPWR VGND VPWR VGND sky130_fd_sc_hd__decap_6
X_1410_ VGND VPWR VPWR VGND _1735_/D _1527_/B _1851_/Q sky130_fd_sc_hd__and2_0
XFILLER_5_385 VPWR VGND VPWR VGND sky130_fd_sc_hd__decap_6
XFILLER_68_348 VGND VPWR VPWR VGND sky130_fd_sc_hd__decap_4
X_1341_ VGND VPWR VGND VPWR _1960_/Q _1331_/B _1169_/Y _1353_/D _1999_/D _1340_/Y
+ sky130_fd_sc_hd__o41ai_1
XFILLER_36_201 VPWR VGND VPWR VGND sky130_fd_sc_hd__decap_6
X_1272_ VGND VPWR VGND VPWR _1328_/B _1281_/A _1272_/Y _1273_/B sky130_fd_sc_hd__o21ai_0
X_0987_ VPWR VGND VPWR VGND _1876_/Q _0997_/A _0998_/A1 _0987_/Y sky130_fd_sc_hd__a21oi_1
X_1608_ VPWR VGND VGND VPWR _1608_/A _1608_/B _1610_/B sky130_fd_sc_hd__nor2_1
X_1539_ VPWR VGND VGND VPWR _1911_/D _1539_/B _1917_/D sky130_fd_sc_hd__nor2_1
Xfanout103 VPWR VGND _1693_/A _1522_/A VPWR VGND sky130_fd_sc_hd__buf_2
XFILLER_67_370 VPWR VGND VPWR VGND sky130_fd_sc_hd__decap_3
XFILLER_42_237 VGND VPWR VPWR VGND sky130_fd_sc_hd__decap_12
XFILLER_12_63 VPWR VGND VPWR VGND sky130_fd_sc_hd__decap_6
XFILLER_12_74 VGND VPWR VPWR VGND sky130_fd_sc_hd__decap_4
XFILLER_2_377 VGND VPWR VPWR VGND sky130_fd_sc_hd__decap_12
XFILLER_2_333 VGND VPWR VPWR VGND sky130_fd_sc_hd__decap_12
XFILLER_33_259 VGND VPWR VPWR VGND sky130_fd_sc_hd__decap_12
XFILLER_33_215 VPWR VGND VPWR VGND sky130_fd_sc_hd__decap_8
XPHY_EDGE_ROW_16_Right_16 VPWR VGND VPWR VGND sky130_fd_sc_hd__decap_3
XFILLER_18_289 VPWR VGND VPWR VGND sky130_fd_sc_hd__decap_3
X_1890_ VPWR VGND clkload7/A _1649_/Y _1890_/Q _1890_/D VPWR VGND sky130_fd_sc_hd__edfxtp_1
X_0841_ VPWR VGND VGND VPWR _1922_/Q _0884_/A sky130_fd_sc_hd__inv_1
X_0910_ VPWR VGND VGND VPWR _0928_/A _0943_/A _1884_/Q _0910_/B sky130_fd_sc_hd__maj3_1
XPHY_EDGE_ROW_25_Right_25 VPWR VGND VPWR VGND sky130_fd_sc_hd__decap_3
XFILLER_45_3 VGND VPWR VPWR VGND sky130_fd_sc_hd__decap_4
X_1255_ VPWR VGND VGND VPWR _1311_/B _1910_/D sky130_fd_sc_hd__inv_1
X_1186_ VGND VPWR VGND VPWR _1182_/Y _1184_/X _1867_/D _1185_/Y sky130_fd_sc_hd__o21ai_0
X_1324_ VPWR VGND VGND VPWR _1324_/C _1324_/B _1324_/A _1324_/Y sky130_fd_sc_hd__nor3_1
XPHY_EDGE_ROW_34_Right_34 VPWR VGND VPWR VGND sky130_fd_sc_hd__decap_3
XPHY_EDGE_ROW_20_Left_92 VPWR VGND VPWR VGND sky130_fd_sc_hd__decap_3
XFILLER_20_421 VGND VPWR VPWR VGND sky130_fd_sc_hd__decap_4
XFILLER_24_248 VGND VPWR VPWR VGND sky130_fd_sc_hd__decap_4
XPHY_EDGE_ROW_43_Right_43 VPWR VGND VPWR VGND sky130_fd_sc_hd__decap_3
XFILLER_59_134 VPWR VGND VPWR VGND sky130_fd_sc_hd__decap_6
XPHY_EDGE_ROW_52_Right_52 VPWR VGND VPWR VGND sky130_fd_sc_hd__decap_3
XFILLER_15_215 VGND VPWR VPWR VGND sky130_fd_sc_hd__decap_4
XFILLER_15_237 VGND VPWR VPWR VGND sky130_fd_sc_hd__decap_4
XPHY_EDGE_ROW_61_Right_61 VPWR VGND VPWR VGND sky130_fd_sc_hd__decap_3
XFILLER_23_95 VGND VPWR VPWR VGND sky130_fd_sc_hd__decap_12
XFILLER_23_270 VPWR VGND VPWR VGND sky130_fd_sc_hd__decap_8
XFILLER_23_281 VPWR VGND VPWR VGND sky130_fd_sc_hd__decap_3
XPHY_EDGE_ROW_70_Right_70 VPWR VGND VPWR VGND sky130_fd_sc_hd__decap_3
XFILLER_2_141 VGND VPWR VPWR VGND sky130_fd_sc_hd__decap_12
XFILLER_46_351 VGND VPWR VPWR VGND sky130_fd_sc_hd__decap_4
X_1040_ VPWR VGND VGND VPWR _1039_/X _1040_/Y _1038_/X _1084_/S sky130_fd_sc_hd__mux2i_1
X_1942_ _1942_/Q _1983_/CLK _1942_/D VPWR VGND VPWR VGND sky130_fd_sc_hd__dfxtp_1
X_1873_ VPWR VGND _1977_/CLK _1653_/Y _1873_/Q _1873_/D VPWR VGND sky130_fd_sc_hd__edfxtp_1
XFILLER_9_64 VGND VPWR VPWR VGND sky130_fd_sc_hd__decap_12
XFILLER_56_137 VPWR VGND VPWR VGND sky130_fd_sc_hd__decap_3
X_1307_ VPWR VGND VGND VPWR _1307_/A _1319_/B _1311_/B sky130_fd_sc_hd__nand2_1
XFILLER_52_321 VGND VPWR VPWR VGND sky130_fd_sc_hd__decap_12
X_1169_ VPWR VGND VGND VPWR _1353_/B _1963_/Q _1169_/Y sky130_fd_sc_hd__nand2b_1
X_1238_ VGND VPWR VPWR VGND _1844_/D _1499_/A1 _1238_/S _1979_/Q sky130_fd_sc_hd__mux2_1
XFILLER_52_365 VGND VPWR VPWR VGND sky130_fd_sc_hd__decap_4
XFILLER_69_69 VGND VPWR VPWR VGND sky130_fd_sc_hd__decap_4
Xclkbuf_3_0__f_clk VGND VPWR VGND VPWR clkbuf_0_clk/X clkbuf_leaf_2_clk/A sky130_fd_sc_hd__clkbuf_16
XFILLER_47_137 VPWR VGND VPWR VGND sky130_fd_sc_hd__decap_3
XFILLER_59_91 VGND VPWR VPWR VGND sky130_fd_sc_hd__decap_4
XFILLER_53_118 VGND VPWR VPWR VGND sky130_fd_sc_hd__decap_12
XFILLER_53_107 VGND VPWR VPWR VGND sky130_fd_sc_hd__decap_4
XFILLER_34_321 VGND VPWR VPWR VGND sky130_fd_sc_hd__decap_4
X_1023_ VGND VPWR VGND VPWR _1083_/S0 _1788_/Q _1772_/Q _1083_/S1 _1804_/Q _1820_/Q
+ _1023_/X sky130_fd_sc_hd__mux4_2
X_1925_ VPWR VGND _1925_/CLK _1925_/DE _1925_/Q _1925_/D VPWR VGND sky130_fd_sc_hd__edfxtp_1
X_1856_ VPWR VGND clkload9/A _1658_/Y _1856_/Q _1856_/D VPWR VGND sky130_fd_sc_hd__edfxtp_1
X_1787_ VPWR VGND _2016_/CLK _1790_/DE _1787_/Q _1787_/D VPWR VGND sky130_fd_sc_hd__edfxtp_1
XPHY_EDGE_ROW_2_Right_2 VPWR VGND VPWR VGND sky130_fd_sc_hd__decap_3
XFILLER_71_15 VGND VPWR VPWR VGND sky130_fd_sc_hd__decap_12
XFILLER_40_346 VGND VPWR VPWR VGND sky130_fd_sc_hd__decap_12
XPHY_EDGE_ROW_33_Left_105 VPWR VGND VPWR VGND sky130_fd_sc_hd__decap_3
XPHY_EDGE_ROW_42_Left_114 VPWR VGND VPWR VGND sky130_fd_sc_hd__decap_3
XFILLER_35_107 VGND VPWR VPWR VGND sky130_fd_sc_hd__decap_4
XFILLER_29_72 VGND VPWR VPWR VGND sky130_fd_sc_hd__decap_12
XPHY_EDGE_ROW_51_Left_123 VPWR VGND VPWR VGND sky130_fd_sc_hd__decap_3
XFILLER_16_365 VPWR VGND VPWR VGND sky130_fd_sc_hd__decap_3
X_1572_ VPWR VGND VPWR VGND _1576_/B _2020_/A _2021_/A _1573_/C sky130_fd_sc_hd__a21o_1
X_1641_ VPWR VGND VGND VPWR _1645_/A _1641_/Y sky130_fd_sc_hd__inv_1
XFILLER_6_65 VGND VPWR VPWR VGND sky130_fd_sc_hd__decap_12
X_1710_ VPWR VGND clkload3/A _1710_/DE _1710_/Q _1710_/D VPWR VGND sky130_fd_sc_hd__edfxtp_1
XFILLER_66_243 VPWR VGND VPWR VGND sky130_fd_sc_hd__decap_8
XPHY_EDGE_ROW_60_Left_132 VPWR VGND VPWR VGND sky130_fd_sc_hd__decap_3
X_1006_ VPWR VGND VGND VPWR _1219_/A _1007_/C _1006_/Y sky130_fd_sc_hd__nor2_1
X_1839_ VPWR VGND _1988_/CLK _1869_/DE _1839_/Q _1839_/D VPWR VGND sky130_fd_sc_hd__edfxtp_1
X_1908_ VPWR VGND _2015_/CLK _1328_/B _2043_/A _1908_/D VPWR VGND sky130_fd_sc_hd__edfxtp_1
XFILLER_1_217 VPWR VGND VPWR VGND sky130_fd_sc_hd__decap_6
XFILLER_57_276 VGND VPWR VPWR VGND sky130_fd_sc_hd__decap_4
Xclkbuf_leaf_37_clk clkload2/A clkbuf_leaf_2_clk/A VPWR VGND VGND VPWR sky130_fd_sc_hd__clkbuf_8
XFILLER_9_317 VGND VPWR VPWR VGND sky130_fd_sc_hd__decap_12
XFILLER_13_368 VGND VPWR VPWR VGND sky130_fd_sc_hd__decap_12
XFILLER_15_52 VGND VPWR VPWR VGND sky130_fd_sc_hd__decap_4
Xplace235 VPWR VGND _1222_/C _1339_/A1 VPWR VGND sky130_fd_sc_hd__buf_2
Xplace213 VPWR VGND _1288_/A1 _1012_/Y VPWR VGND sky130_fd_sc_hd__buf_2
Xplace257 VPWR VGND _0992_/A _0852_/Y VPWR VGND sky130_fd_sc_hd__buf_2
Xplace268 VPWR VGND _1238_/S _1349_/S VPWR VGND sky130_fd_sc_hd__buf_2
Xplace202 VPWR VGND _2008_/DE _1922_/DE VPWR VGND sky130_fd_sc_hd__buf_2
Xplace279 VPWR VGND _1286_/S1 _1064_/S1 VPWR VGND sky130_fd_sc_hd__buf_2
Xplace246 VPWR VGND _1525_/B _1276_/Y VPWR VGND sky130_fd_sc_hd__buf_2
Xclkbuf_leaf_28_clk _1895_/CLK clkbuf_3_5__f_clk/X VPWR VGND VGND VPWR sky130_fd_sc_hd__clkbuf_8
Xplace224 VPWR VGND _1737_/DE _1742_/DE VPWR VGND sky130_fd_sc_hd__buf_2
XFILLER_71_290 VGND VPWR VPWR VGND sky130_fd_sc_hd__decap_4
XFILLER_31_198 VGND VPWR VPWR VGND sky130_fd_sc_hd__decap_12
XFILLER_31_165 VPWR VGND VPWR VGND sky130_fd_sc_hd__decap_3
XFILLER_31_132 VPWR VGND VPWR VGND sky130_fd_sc_hd__decap_8
X_1555_ VPWR VGND VGND VPWR _2025_/A _1555_/B _1556_/C sky130_fd_sc_hd__nor2_1
X_1624_ VGND VPWR VPWR VGND _1787_/D _1629_/B _1855_/Q sky130_fd_sc_hd__and2_0
Xclkbuf_leaf_19_clk _1967_/CLK clkload0/A VPWR VGND VGND VPWR sky130_fd_sc_hd__clkbuf_8
XFILLER_54_224 VGND VPWR VPWR VGND sky130_fd_sc_hd__decap_12
X_1486_ VPWR VGND VGND VPWR _1673_/A _1632_/B _1956_/D sky130_fd_sc_hd__nor2_1
XFILLER_36_29 VPWR VGND VPWR VGND sky130_fd_sc_hd__decap_3
XFILLER_27_405 VGND VPWR VPWR VGND sky130_fd_sc_hd__decap_12
X_2038_ VPWR VGND _2038_/X _2038_/A VPWR VGND sky130_fd_sc_hd__buf_2
XFILLER_10_305 VPWR VGND VPWR VGND sky130_fd_sc_hd__decap_3
XFILLER_6_309 VGND VPWR VPWR VGND sky130_fd_sc_hd__decap_12
Xhold394 _1836_/D _1941_/Q VPWR VGND VGND VPWR sky130_fd_sc_hd__dlygate4sd3_1
Xhold383 _2006_/D _1812_/Q VPWR VGND VGND VPWR sky130_fd_sc_hd__dlygate4sd3_1
Xhold372 _2016_/D _1822_/Q VPWR VGND VGND VPWR sky130_fd_sc_hd__dlygate4sd3_1
Xhold361 _1907_/D _2014_/Q VPWR VGND VGND VPWR sky130_fd_sc_hd__dlygate4sd3_1
Xhold350 _1901_/D _2008_/Q VPWR VGND VGND VPWR sky130_fd_sc_hd__dlygate4sd3_1
X_1340_ VPWR VGND VGND VPWR _1340_/A _1340_/Y _1353_/D sky130_fd_sc_hd__nand2_1
X_1271_ VPWR VGND VGND VPWR _1528_/B _1273_/B _1281_/A sky130_fd_sc_hd__nor2_4
Xclkbuf_leaf_8_clk _1977_/CLK clkbuf_leaf_9_clk/A VPWR VGND VGND VPWR sky130_fd_sc_hd__clkbuf_8
X_0986_ VGND VPWR _0986_/B _0986_/Y _0986_/A VPWR VGND sky130_fd_sc_hd__xnor2_1
X_1607_ VGND VPWR _1607_/B _1608_/B _2028_/A VPWR VGND sky130_fd_sc_hd__xnor2_1
X_1469_ VPWR VGND VPWR VGND _1466_/Y _1573_/A _1468_/Y _1966_/D sky130_fd_sc_hd__a21oi_1
X_1538_ VPWR VGND VGND VPWR _1959_/Q _1538_/B _1539_/B sky130_fd_sc_hd__nor2_1
Xfanout104 VPWR VGND _1522_/A _1686_/A VPWR VGND sky130_fd_sc_hd__buf_2
XFILLER_67_393 VGND VPWR VPWR VGND sky130_fd_sc_hd__decap_12
XFILLER_47_39 VGND VPWR VPWR VGND sky130_fd_sc_hd__decap_12
XFILLER_42_249 VPWR VGND VPWR VGND sky130_fd_sc_hd__decap_3
XFILLER_5_3 VGND VPWR VPWR VGND sky130_fd_sc_hd__decap_12
XFILLER_2_345 VGND VPWR VPWR VGND sky130_fd_sc_hd__decap_12
XFILLER_65_319 VGND VPWR VPWR VGND sky130_fd_sc_hd__decap_4
XFILLER_2_389 VGND VPWR VPWR VGND sky130_fd_sc_hd__decap_12
XFILLER_41_260 VPWR VGND VPWR VGND sky130_fd_sc_hd__decap_8
X_0840_ VPWR VGND VGND VPWR _1921_/Q _0840_/Y sky130_fd_sc_hd__inv_1
XFILLER_68_135 VGND VPWR VPWR VGND sky130_fd_sc_hd__decap_4
X_1323_ VPWR VGND VGND VPWR _1323_/A _1323_/B _1324_/C sky130_fd_sc_hd__nor2_1
X_1185_ VGND VPWR VGND VPWR _1207_/B _1140_/B _1185_/Y _1339_/A1 sky130_fd_sc_hd__o21ai_0
X_1254_ VPWR VGND VGND VPWR _1960_/Q _1311_/B _1305_/A sky130_fd_sc_hd__nand2_1
XFILLER_49_393 VGND VPWR VPWR VGND sky130_fd_sc_hd__decap_4
X_0969_ VGND VPWR VGND VPWR _0968_/Y _0992_/A _1984_/D _0965_/Y sky130_fd_sc_hd__o21ai_0
XFILLER_2_197 VPWR VGND VPWR VGND sky130_fd_sc_hd__decap_8
XFILLER_2_153 VGND VPWR VPWR VGND sky130_fd_sc_hd__decap_12
XFILLER_48_71 VGND VPWR VPWR VGND sky130_fd_sc_hd__decap_4
XFILLER_64_81 VPWR VGND VPWR VGND sky130_fd_sc_hd__decap_3
X_1941_ _1941_/Q _1983_/CLK _1941_/D VPWR VGND VPWR VGND sky130_fd_sc_hd__dfxtp_1
XFILLER_61_333 VPWR VGND VPWR VGND sky130_fd_sc_hd__decap_3
X_1872_ VPWR VGND _1977_/CLK _1651_/Y _1872_/Q _1872_/D VPWR VGND sky130_fd_sc_hd__edfxtp_1
XFILLER_9_76 VGND VPWR VPWR VGND sky130_fd_sc_hd__decap_12
X_1306_ VPWR VGND VPWR VGND _1360_/A _1305_/Y _1306_/Y _1293_/Y _1303_/Y sky130_fd_sc_hd__a22oi_1
X_1168_ VPWR VGND VGND VPWR _1961_/Q _1304_/C _1960_/Q sky130_fd_sc_hd__nor2_2
XFILLER_52_344 VGND VPWR VPWR VGND sky130_fd_sc_hd__decap_12
X_1237_ VGND VPWR VPWR VGND _1845_/D _1497_/A1 _1238_/S _1980_/Q sky130_fd_sc_hd__mux2_1
X_1099_ VGND VPWR VGND VPWR _1130_/S0 _1737_/Q _1705_/Q _1130_/S1 _1769_/Q _1801_/Q
+ _1099_/X sky130_fd_sc_hd__mux4_2
XFILLER_69_15 VGND VPWR VPWR VGND sky130_fd_sc_hd__decap_12
XFILLER_18_85 VGND VPWR VPWR VGND sky130_fd_sc_hd__decap_12
XFILLER_43_366 VGND VPWR VPWR VGND sky130_fd_sc_hd__decap_12
XFILLER_61_152 VGND VPWR VPWR VGND sky130_fd_sc_hd__decap_12
XFILLER_38_149 VPWR VGND VPWR VGND sky130_fd_sc_hd__decap_8
X_1022_ VGND VPWR VGND VPWR _1083_/S0 _1724_/Q _1708_/Q _1083_/S1 _1740_/Q _1756_/Q
+ _1022_/X sky130_fd_sc_hd__mux4_2
X_1924_ VPWR VGND _1987_/CLK _1925_/DE _1924_/Q _1924_/D VPWR VGND sky130_fd_sc_hd__edfxtp_1
X_1855_ VPWR VGND _1963_/CLK _1659_/Y _1855_/Q _1855_/D VPWR VGND sky130_fd_sc_hd__edfxtp_1
X_1786_ VPWR VGND _2000_/CLK _1786_/DE _1786_/Q _1786_/D VPWR VGND sky130_fd_sc_hd__edfxtp_1
XFILLER_40_358 VPWR VGND VPWR VGND sky130_fd_sc_hd__decap_3
XFILLER_25_355 VGND VPWR VPWR VGND sky130_fd_sc_hd__decap_4
XFILLER_4_237 VGND VPWR VPWR VGND sky130_fd_sc_hd__decap_12
Xinput300 VPWR VGND _1485_/A1 mem_rdata[8] VPWR VGND sky130_fd_sc_hd__buf_4
XFILLER_0_421 VGND VPWR VPWR VGND sky130_fd_sc_hd__decap_4
XFILLER_63_417 VPWR VGND VPWR VGND sky130_fd_sc_hd__decap_3
XFILLER_61_60 VGND VPWR VPWR VGND sky130_fd_sc_hd__decap_4
XFILLER_43_163 VGND VPWR VPWR VGND sky130_fd_sc_hd__decap_4
X_1571_ VPWR VGND VPWR VGND _1570_/Y _1569_/Y _1682_/A _1970_/D sky130_fd_sc_hd__a21oi_1
X_1640_ VPWR VGND VGND VPWR _1645_/A _1640_/Y sky130_fd_sc_hd__inv_1
XFILLER_6_77 VPWR VGND VPWR VGND sky130_fd_sc_hd__decap_6
XFILLER_3_281 VGND VPWR VPWR VGND sky130_fd_sc_hd__decap_12
XFILLER_26_119 VGND VPWR VPWR VGND sky130_fd_sc_hd__decap_12
XFILLER_20_3 VGND VPWR VPWR VGND sky130_fd_sc_hd__decap_12
X_1005_ VPWR VGND VGND VPWR _1007_/C _1005_/B _1357_/B sky130_fd_sc_hd__nor2_1
X_1838_ VPWR VGND _1987_/CLK _1869_/DE _1838_/Q _1838_/D VPWR VGND sky130_fd_sc_hd__edfxtp_1
X_1907_ VPWR VGND _2001_/CLK _1633_/Y _2042_/A _1907_/D VPWR VGND sky130_fd_sc_hd__edfxtp_1
X_1769_ VPWR VGND _1788_/CLK _1774_/DE _1769_/Q _1769_/D VPWR VGND sky130_fd_sc_hd__edfxtp_1
XFILLER_25_141 VGND VPWR VPWR VGND sky130_fd_sc_hd__decap_12
XFILLER_9_329 VPWR VGND VPWR VGND sky130_fd_sc_hd__decap_6
XFILLER_13_347 VGND VPWR VPWR VGND sky130_fd_sc_hd__decap_4
XFILLER_0_240 VGND VPWR VPWR VGND sky130_fd_sc_hd__decap_12
XFILLER_0_295 VGND VPWR VPWR VGND sky130_fd_sc_hd__decap_12
Xplace269 VPWR VGND _1349_/S _1913_/Q VPWR VGND sky130_fd_sc_hd__buf_4
Xplace214 VPWR VGND _1608_/A _1459_/B VPWR VGND sky130_fd_sc_hd__buf_2
Xplace236 VPWR VGND _1339_/A1 _1305_/C VPWR VGND sky130_fd_sc_hd__buf_2
Xplace258 VPWR VGND _0997_/A _1997_/Q VPWR VGND sky130_fd_sc_hd__buf_2
Xplace203 VPWR VGND _1922_/DE _1925_/DE VPWR VGND sky130_fd_sc_hd__buf_2
Xplace225 VPWR VGND _1742_/DE _1274_/Y VPWR VGND sky130_fd_sc_hd__buf_2
Xplace247 VPWR VGND _1621_/B _1613_/B VPWR VGND sky130_fd_sc_hd__buf_2
XFILLER_16_141 VPWR VGND VPWR VGND sky130_fd_sc_hd__decap_8
XFILLER_68_3 VGND VPWR VPWR VGND sky130_fd_sc_hd__decap_12
XFILLER_31_177 VPWR VGND VPWR VGND sky130_fd_sc_hd__decap_3
X_1554_ VPWR VGND _1974_/D _1671_/A _1553_/Y _1553_/B _1551_/Y _1552_/Y VPWR VGND
+ sky130_fd_sc_hd__a311oi_1
X_1485_ VPWR VGND VGND VPWR _1140_/B _1632_/B _1485_/A1 _1584_/S sky130_fd_sc_hd__mux2i_1
X_1623_ VGND VPWR VPWR VGND _1788_/D _1629_/B _1856_/Q sky130_fd_sc_hd__and2_0
.ends
